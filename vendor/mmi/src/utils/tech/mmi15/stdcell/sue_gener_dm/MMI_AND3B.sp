* FILE: MMI_AND3B.sp

 ********************** begin header *****************************

* Header file for TSMC 0.15 um CMOS (1.5V)

.OPTIONS post ACCT OPTS lvltim=2 NOMOD

.option gmindc=   10.0p

**################################################
.options brief
.lib '/volume/mmi_proj/proj/tech/mmi15/spice/tsmc15.mod' TT
.options brief=0
* Allowed corners: TT, FF, SS, FS, SF

* Note: min W is 0.18 um
**################################################

.param  arean(w,sdd) = '(w*sdd*1p)'
.param  areap(w,sdd) = '(w*sdd*1p)'
.param  perin(w,sdd) = '(2u*(w+sdd))'
.param  perip(w,sdd) = '(2u*(w+sdd))'

.param ln_min   =  0.15u
.param lp_min   =  0.15u

* used in source/drain area/perimeter calculation
.param sdd        =  0.395

.PARAM vddp=1.35		$ VDD voltage

VDD vdd 0 DC vddp

.TEMP 105
.TRAN 10p 10n
*********************** end header ******************************

* SPICE netlist for "MMI_AND3B" (generated by MMI_SUE4.3.3)

.SUBCKT inverter1 in out WP=2 LP=lp_min WN=1 LN=ln_min delay=0
M_0 out in gnd gnd n W='WN*1u' L=LN ad='arean(WN,sdd)' as='arean(WN,sdd)'
+ pd='perin(WN,sdd)' ps='perin(WN,sdd)'
M_1 out in vdd vdd p W='WP*1u' L=LP ad='areap(WP,sdd)' as='areap(WP,sdd)'
+ pd='perip(WP,sdd)' ps='perip(WP,sdd)'
.ENDS	$ inverter1

* start main CELL MMI_AND3B
* .SUBCKT MMI_AND3B in0 in1 in2 out
Xinverter1 N1 out inverter1 WP=1.54 WN=0.77
M_0 N1 in2 vdd vdd p W='0.77*1u' L=lp_min ad='areap(0.77,sdd)'
+ as='areap(0.77,sdd)' pd='perip(0.77,sdd)' ps='perip(0.77,sdd)'
M_1 N1 in1 vdd vdd p W='0.77*1u' L=lp_min ad='areap(0.77,sdd)'
+ as='areap(0.77,sdd)' pd='perip(0.77,sdd)' ps='perip(0.77,sdd)'
M_2 N1 in0 vdd vdd p W='0.77*1u' L=lp_min ad='areap(0.77,sdd)'
+ as='areap(0.77,sdd)' pd='perip(0.77,sdd)' ps='perip(0.77,sdd)'
M_3 N1 in0 net_1 gnd n W='1.155*1u' L=ln_min ad='arean(1.155,sdd)'
+ as='arean(1.155,sdd)' pd='perin(1.155,sdd)' ps='perin(1.155,sdd)'
M_4 net_1 in1 net_2 gnd n W='1.155*1u' L=ln_min ad='arean(1.155,sdd)'
+ as='arean(1.155,sdd)' pd='perin(1.155,sdd)' ps='perin(1.155,sdd)'
M_5 net_2 in2 gnd gnd n W='1.155*1u' L=ln_min ad='arean(1.155,sdd)'
+ as='arean(1.155,sdd)' pd='perin(1.155,sdd)' ps='perin(1.155,sdd)'
* .ENDS	$ MMI_AND3B

.GLOBAL gnd vdd

.END
