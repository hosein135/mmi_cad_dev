*** Extracted spice netlist generated from MAX ***

.SUBCKT MMI_MUXI2C in0 in1 out sel
C_1 vdd gnd 4.42976fF
C_2 in0 gnd 1.52529fF
C_3 net_1 gnd 3.3101fF
C_4 sel gnd 3.35408fF
C_5 out gnd 3.32173fF
C_6 net_2 gnd 3.47504fF
C_7 net_3 gnd 3.44646fF
C_8 in1 gnd 1.66057fF
C_9 gnd gnd 3.5531fF
Mp_1 vdd in0 net_1 vdd p W=2.055U L=0.15U AD=0.532426P PD=3.0788U
+ AS=0.4521P PS=2.495U
Mp_2 net_1 in0 vdd vdd p W=2.055U L=0.15U AD=0.4521P PD=2.495U AS=0.532426P
+ PS=3.0788U
Mp_3 vdd in0 net_1 vdd p W=2.055U L=0.15U AD=0.532426P PD=3.0788U
+ AS=0.4521P PS=2.495U
Mp_4 net_1 sel out vdd p W=2.055U L=0.15U AD=0.4521P PD=2.495U AS=0.455525P
+ PS=2.49833U
Mp_5 out sel net_1 vdd p W=2.055U L=0.15U AD=0.455525P PD=2.49833U
+ AS=0.4521P PS=2.495U
Mp_6 net_1 sel out vdd p W=2.055U L=0.15U AD=0.4521P PD=2.495U AS=0.455525P
+ PS=2.49833U
Mp_7 out net_2 net_3 vdd p W=2.055U L=0.15U AD=0.455525P PD=2.49833U
+ AS=0.462375P PS=2.505U
Mp_8 net_3 net_2 out vdd p W=2.055U L=0.15U AD=0.462375P PD=2.505U
+ AS=0.455525P PS=2.49833U
Mp_9 out net_2 net_3 vdd p W=2.055U L=0.15U AD=0.455525P PD=2.49833U
+ AS=0.462375P PS=2.505U
Mp_10 net_3 in1 vdd vdd p W=2.055U L=0.15U AD=0.462375P PD=2.505U
+ AS=0.532426P PS=3.0788U
Mp_11 vdd in1 net_3 vdd p W=2.055U L=0.15U AD=0.532426P PD=3.0788U
+ AS=0.462375P PS=2.505U
Mp_12 net_3 in1 vdd vdd p W=2.055U L=0.15U AD=0.462375P PD=2.505U
+ AS=0.532426P PS=3.0788U
Mp_13 vdd sel net_2 vdd p W=1.54U L=0.15U AD=0.398995P PD=2.30722U
+ AS=0.6083P PS=3.87U
Mn_1 gnd in0 net_1 gnd n W=1.025U L=0.15U AD=0.271103P PD=2.00112U
+ AS=0.2255P PS=1.465U
Mn_2 net_1 in0 gnd gnd n W=1.025U L=0.15U AD=0.2255P PD=1.465U AS=0.271103P
+ PS=2.00112U
Mn_3 gnd in0 net_1 gnd n W=1.025U L=0.15U AD=0.271103P PD=2.00112U
+ AS=0.2255P PS=1.465U
Mn_4 net_1 net_2 out gnd n W=1.025U L=0.15U AD=0.2255P PD=1.465U
+ AS=0.228062P PS=1.47U
Mn_5 out net_2 net_1 gnd n W=1.025U L=0.15U AD=0.228062P PD=1.47U
+ AS=0.2255P PS=1.465U
Mn_6 net_1 net_2 out gnd n W=1.025U L=0.15U AD=0.2255P PD=1.465U
+ AS=0.228062P PS=1.47U
Mn_7 out sel net_3 gnd n W=1.025U L=0.15U AD=0.228062P PD=1.47U
+ AS=0.255396P PS=1.52333U
Mn_8 net_3 sel out gnd n W=1.025U L=0.15U AD=0.255396P PD=1.52333U
+ AS=0.228062P PS=1.47U
Mn_9 out sel net_3 gnd n W=1.025U L=0.15U AD=0.228062P PD=1.47U
+ AS=0.255396P PS=1.52333U
Mn_10 net_3 in1 gnd gnd n W=1.025U L=0.15U AD=0.255396P PD=1.52333U
+ AS=0.271103P PS=2.00112U
Mn_11 gnd in1 net_3 gnd n W=1.025U L=0.15U AD=0.271103P PD=2.00112U
+ AS=0.255396P PS=1.52333U
Mn_12 net_3 in1 gnd gnd n W=1.025U L=0.15U AD=0.255396P PD=1.52333U
+ AS=0.271103P PS=2.00112U
Mn_13 gnd sel net_2 gnd n W=0.77U L=0.15U AD=0.203658P PD=1.50328U
+ AS=0.30415P PS=2.33U
.ENDS	$ MMI_MUXI2C

.GLOBAL gnd vdd
