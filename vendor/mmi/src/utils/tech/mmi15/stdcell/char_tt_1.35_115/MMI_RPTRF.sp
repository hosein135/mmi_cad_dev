*** Extracted spice netlist generated from MAX ***

.SUBCKT MMI_RPTRF in out
C_1 out gnd 7.89749fF
C_2 in gnd 4.46806fF
C_3 vdd gnd 4.93855fF
C_4 gnd gnd 4.45185fF
Mp_1 out in vdd vdd p W=2.06U L=0.15U AD=0.527875P PD=2.91583U AS=0.466933P
+ PS=2.51333U
Mp_2 vdd in out vdd p W=2.06U L=0.15U AD=0.466933P PD=2.51333U AS=0.527875P
+ PS=2.91583U
Mp_3 out in vdd vdd p W=2.06U L=0.15U AD=0.527875P PD=2.91583U AS=0.466933P
+ PS=2.51333U
Mp_4 vdd in out vdd p W=2.06U L=0.15U AD=0.466933P PD=2.51333U AS=0.527875P
+ PS=2.91583U
Mp_5 out in vdd vdd p W=2.06U L=0.15U AD=0.527875P PD=2.91583U AS=0.466933P
+ PS=2.51333U
Mp_6 vdd in out vdd p W=2.06U L=0.15U AD=0.466933P PD=2.51333U AS=0.527875P
+ PS=2.91583U
Mp_7 out in vdd vdd p W=2.06U L=0.15U AD=0.527875P PD=2.91583U AS=0.466933P
+ PS=2.51333U
Mp_8 vdd in out vdd p W=2.06U L=0.15U AD=0.466933P PD=2.51333U AS=0.527875P
+ PS=2.91583U
Mp_9 out in vdd vdd p W=2.06U L=0.15U AD=0.527875P PD=2.91583U AS=0.466933P
+ PS=2.51333U
Mp_10 vdd in out vdd p W=2.06U L=0.15U AD=0.466933P PD=2.51333U
+ AS=0.527875P PS=2.91583U
Mp_11 out in vdd vdd p W=2.06U L=0.15U AD=0.527875P PD=2.91583U
+ AS=0.466933P PS=2.51333U
Mp_12 vdd in out vdd p W=2.06U L=0.15U AD=0.466933P PD=2.51333U
+ AS=0.527875P PS=2.91583U
Mn_1 out in gnd gnd n W=1.54U L=0.15U AD=0.417725P PD=2.4675U AS=0.4851P
+ PS=2.94U
Mn_2 gnd in out gnd n W=1.54U L=0.15U AD=0.4851P PD=2.94U AS=0.417725P
+ PS=2.4675U
Mn_3 out in gnd gnd n W=1.54U L=0.15U AD=0.417725P PD=2.4675U AS=0.4851P
+ PS=2.94U
Mn_4 gnd in out gnd n W=1.54U L=0.15U AD=0.4851P PD=2.94U AS=0.417725P
+ PS=2.4675U
Mn_5 out in gnd gnd n W=1.54U L=0.15U AD=0.417725P PD=2.4675U AS=0.4851P
+ PS=2.94U
Mn_6 gnd in out gnd n W=1.54U L=0.15U AD=0.4851P PD=2.94U AS=0.417725P
+ PS=2.4675U
Mn_7 out in gnd gnd n W=1.54U L=0.15U AD=0.417725P PD=2.4675U AS=0.4851P
+ PS=2.94U
Mn_8 gnd in out gnd n W=1.54U L=0.15U AD=0.4851P PD=2.94U AS=0.417725P
+ PS=2.4675U
.ENDS	$ MMI_RPTRF

.GLOBAL gnd vdd
