* FILE: MMI_KEEPW.sp

* SPICE netlist for "MMI_KEEPW" (generated by MMI_SUE4.2.16)

.SUBCKT MMI_KEEPW in
M_0 in net_1 vdd vdd p W='0.35*1u' L=lp_min
M_1_1 net_1 in vdd vdd p W='0.35*1u' L=lp_min
M_2_1 in net_1 gnd gnd n W='0.35*1u' L='2*ln_min'
M_3_1 net_1 in gnd gnd n W='0.35*1u' L='2*ln_min'
.ENDS	$ MMI_KEEPW
