* FILE: MMI_XNOR2A.sp

* SPICE netlist for "MMI_XNOR2A" (generated by MMI_SUE4.2.16)

.SUBCKT MMI_XNOR2A in0 in1 out
MMMI_NAND2A._0 MMI_NAND2A%net_1 in1 gnd gnd n W='0.77*1u' L=ln_min
MMMI_NAND2A._1 net_1 in0 MMI_NAND2A%net_1 gnd n W='0.77*1u' L=ln_min
MMMI_NAND2A._2 net_1 in1 vdd vdd p W='0.77*1u' L=lp_min
MMMI_NAND2A._3 net_1 in0 vdd vdd p W='0.77*1u' L=lp_min
MMMI_OAI21A._4 out net_1 MMI_OAI21A%net_1 gnd n W='0.77*1u' L=ln_min
MMMI_OAI21A._5 MMI_OAI21A%net_1 in1 gnd gnd n W='0.77*1u' L=ln_min
MMMI_OAI21A._6 MMI_OAI21A%net_1 in0 gnd gnd n W='0.77*1u' L=ln_min
MMMI_OAI21A._7 out net_1 vdd vdd p W='0.77*1u' L=lp_min
MMMI_OAI21A._8 out in1 MMI_OAI21A%net_2 vdd p W='1.54*1u' L=lp_min
MMMI_OAI21A._9 MMI_OAI21A%net_2 in0 vdd vdd p W='1.54*1u' L=lp_min
.ENDS	$ MMI_XNOR2A
