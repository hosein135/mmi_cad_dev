* FILE: MMI_FFMB.sp

* SPICE netlist for "MMI_FFMB" (generated by MMI_SUE4.2.16)

.SUBCKT MMI_FFMB clk d0 d1 q sel
Minverter._0 q N5 gnd gnd n W='0.77*1u' L=ln_min
Minverter._1 q N5 vdd vdd p W='1.54*1u' L=lp_min
M_2_1 N1 d0 net_1 vdd p W='1.54*1u' L=lp_min
M_3_1 N1 d0 net_8 gnd n W='0.77*1u' L=ln_min
Minverter_1._4 clk_L clk gnd gnd n W='0.385*1u' L=ln_min
Minverter_1._5 clk_L clk vdd vdd p W='0.77*1u' L=lp_min
M_6_1 net_4 N5 gnd gnd n W='0.35*1u' L=ln_min
M_7_1 N4 clk net_2 vdd p W='0.35*1u' L=lp_min
M_8_1 N4 clk_L net_4 gnd n W='0.35*1u' L=ln_min
M_9_1 net_2 N5 vdd vdd p W='0.35*1u' L=lp_min
M_10_1 net_7 N3 vdd vdd p W='0.35*1u' L=lp_min
M_11_1 N2 clk_L net_7 vdd p W='0.35*1u' L=lp_min
M_12_1 N2 clk net_6 gnd n W='0.35*1u' L=ln_min
M_13_1 net_6 N3 gnd gnd n W='0.35*1u' L=ln_min
Mxgate._14 N4 clk_L N3 vdd p W='0.77*1u' L=lp_min
Mxgate._15 N4 clk N3 gnd n W='0.35*1u' L=ln_min
Mxgate_1._16 N1 clk N2 vdd p W='0.77*1u' L=lp_min
Mxgate_1._17 N1 clk_L N2 gnd n W='0.35*1u' L=ln_min
Minverter_2._18 N5 N4 gnd gnd n W='0.52*1u' L=ln_min
Minverter_2._19 N5 N4 vdd vdd p W='0.77*1u' L=lp_min
Minverter_3._20 N3 N2 gnd gnd n W='0.385*1u' L=ln_min
Minverter_3._21 N3 N2 vdd vdd p W='0.77*1u' L=lp_min
M_22_1 net_1 sel vdd vdd p W='1.54*1u' L=lp_min
M_23_1 N1 d1 net_3 vdd p W='1.54*1u' L=lp_min
M_24_1 net_3 sel_L vdd vdd p W='1.54*1u' L=lp_min
M_25_1 net_8 sel_L gnd gnd n W='0.77*1u' L=ln_min
M_26_1 net_5 sel gnd gnd n W='0.77*1u' L=ln_min
M_27_1 N1 d1 net_5 gnd n W='0.77*1u' L=ln_min
Minverter_4._28 sel_L sel gnd gnd n W='0.385*1u' L=ln_min
Minverter_4._29 sel_L sel vdd vdd p W='0.77*1u' L=lp_min
.ic N4=0V
.ENDS	$ MMI_FFMB
