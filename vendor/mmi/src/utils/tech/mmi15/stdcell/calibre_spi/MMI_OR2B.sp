* FILE: MMI_OR2B.sp

* SPICE netlist for "MMI_OR2B" (generated by MMI_SUE4.2.16)

.SUBCKT MMI_OR2B in0 in1 out
Minverter1._0 out N1 gnd gnd n W='0.77*1u' L=ln_min
Minverter1._1 out N1 vdd vdd p W='1.54*1u' L=lp_min
M_2_1 N1 in1 gnd gnd n W='0.385*1u' L=ln_min
M_3_1 N1 in0 net_1 vdd p W='1.54*1u' L=lp_min
M_4_1 net_1 in1 vdd vdd p W='1.54*1u' L=lp_min
M_5_1 N1 in0 gnd gnd n W='0.385*1u' L=ln_min
.ENDS	$ MMI_OR2B
