* FILE: MMI_AO21B.sp

* SPICE netlist for "MMI_AO21B" (generated by MMI_SUE4.2.16)

.SUBCKT MMI_AO21B in0 in1 in2 out
Minverter1._0 out N1 gnd gnd n W='0.77*1u' L=ln_min
Minverter1._1 out N1 vdd vdd p W='1.54*1u' L=lp_min
M_2_1 N1 in0 gnd gnd n W='0.385*1u' L=ln_min
M_3_1 N1 in1 net_1 gnd n W='0.77*1u' L=ln_min
M_4_1 net_1 in2 gnd gnd n W='0.77*1u' L=ln_min
M_5_1 net_2 in1 vdd vdd p W='1.54*1u' L=lp_min
M_6_1 net_2 in2 vdd vdd p W='1.54*1u' L=lp_min
M_7_1 N1 in0 net_2 vdd p W='1.54*1u' L=lp_min
.ENDS	$ MMI_AO21B
