* FILE: MMI_AND2C.sp

* SPICE netlist for "MMI_AND2C" (generated by MMI_SUE4.2.16)

.SUBCKT MMI_AND2C in0 in1 out
Minverter1._0 out N1 gnd gnd n W='1.54*1u' L=ln_min
Minverter1._1 out N1 vdd vdd p W='3.08*1u' L=lp_min
M_2_1 N1 in0 net_1 gnd n W='1.04*1u' L=ln_min
M_3_1 net_1 in1 gnd gnd n W='1.04*1u' L=ln_min
M_4_1 N1 in0 vdd vdd p W='1.04*1u' L=lp_min
M_5_1 N1 in1 vdd vdd p W='1.04*1u' L=lp_min
.ENDS	$ MMI_AND2C
