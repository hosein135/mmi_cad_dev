* FILE: MMI_OA31C.sp

* SPICE netlist for "MMI_OA31C" (generated by MMI_SUE4.2.16)

.SUBCKT MMI_OA31C in0 in1 in2 in3 out
Minverter1._0 out N1 gnd gnd n W='1.54*1u' L=ln_min
Minverter1._1 out N1 vdd vdd p W='3.08*1u' L=lp_min
M_2_1 N1 in0 net_1 gnd n W='1.04*1u' L=ln_min
M_3_1 net_1 in1 gnd gnd n W='1.04*1u' L=ln_min
M_4_1 net_1 in2 gnd gnd n W='1.04*1u' L=ln_min
M_5_1 net_1 in3 gnd gnd n W='1.04*1u' L=ln_min
M_6_1 N1 in0 vdd vdd p W='1.04*1u' L=lp_min
M_7_1 net_3 in3 vdd vdd p W='1.56*1u' L=lp_min
M_8_1 net_2 in3 vdd vdd p W='1.56*1u' L=lp_min
M_9_1 net_5 in2 net_2 vdd p W='1.56*1u' L=lp_min
M_10_1 N1 in1 net_5 vdd p W='1.56*1u' L=lp_min
M_11_1 net_4 in2 net_3 vdd p W='1.56*1u' L=lp_min
M_12_1 N1 in1 net_4 vdd p W='1.56*1u' L=lp_min
.ENDS	$ MMI_OA31C
