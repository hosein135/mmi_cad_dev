* FILE: MMI_NAND2B.sp

* SPICE netlist for "MMI_NAND2B" (generated by MMI_SUE4.2.16)

.SUBCKT MMI_NAND2B in0 in1 out
M_0 net_1 in1 gnd gnd n W='1.54*1u' L=ln_min
M_1_1 out in0 net_1 gnd n W='1.54*1u' L=ln_min
M_2_1 out in1 vdd vdd p W='1.54*1u' L=lp_min
M_3_1 out in0 vdd vdd p W='1.54*1u' L=lp_min
.ENDS	$ MMI_NAND2B
