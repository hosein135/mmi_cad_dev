* FILE: MMI_MUXI4B.sp

* SPICE netlist for "MMI_MUXI4B" (generated by MMI_SUE4.2.16)

.SUBCKT MMI_MUXI4B in0 in1 in2 in3 out sel0 sel1
Mxgate._0 N2 sel1 N1 vdd p W='1.54*1u' L=lp_min
Mxgate._1 N2 sel1_L N1 gnd n W='0.77*1u' L=ln_min
Mxgate_1._2 N2 sel1_L N3 vdd p W='1.54*1u' L=lp_min
Mxgate_1._3 N2 sel1 N3 gnd n W='0.77*1u' L=ln_min
Minverter._4 sel1_L sel1 gnd gnd n W='0.385*1u' L=ln_min
Minverter._5 sel1_L sel1 vdd vdd p W='0.77*1u' L=lp_min
Mxgate_2._6 net_3 sel0 net_6 vdd p W='1.54*1u' L=lp_min
Mxgate_2._7 net_3 sel0_L net_6 gnd n W='0.77*1u' L=ln_min
Minverter_1._8 net_6 in0 gnd gnd n W='0.77*1u' L=ln_min
Minverter_1._9 net_6 in0 vdd vdd p W='1.54*1u' L=lp_min
Mxgate_3._10 net_3 sel0_L net_2 vdd p W='1.54*1u' L=lp_min
Mxgate_3._11 net_3 sel0 net_2 gnd n W='0.77*1u' L=ln_min
Minverter_2._12 net_2 in1 gnd gnd n W='0.77*1u' L=ln_min
Minverter_2._13 net_2 in1 vdd vdd p W='1.54*1u' L=lp_min
Minverter_3._14 out N2 gnd gnd n W='0.77*1u' L=ln_min
Minverter_3._15 out N2 vdd vdd p W='1.54*1u' L=lp_min
Minverter_4._16 N1 net_3 gnd gnd n W='0.77*1u' L=ln_min
Minverter_4._17 N1 net_3 vdd vdd p W='1.54*1u' L=lp_min
Mxgate_4._18 net_5 sel0 net_4 vdd p W='1.54*1u' L=lp_min
Mxgate_4._19 net_5 sel0_L net_4 gnd n W='0.77*1u' L=ln_min
Minverter_5._20 net_4 in2 gnd gnd n W='0.77*1u' L=ln_min
Minverter_5._21 net_4 in2 vdd vdd p W='1.54*1u' L=lp_min
Mxgate_5._22 net_5 sel0_L net_1 vdd p W='1.54*1u' L=lp_min
Mxgate_5._23 net_5 sel0 net_1 gnd n W='0.77*1u' L=ln_min
Minverter_6._24 net_1 in3 gnd gnd n W='0.77*1u' L=ln_min
Minverter_6._25 net_1 in3 vdd vdd p W='1.54*1u' L=lp_min
Minverter_7._26 N3 net_5 gnd gnd n W='0.77*1u' L=ln_min
Minverter_7._27 N3 net_5 vdd vdd p W='1.54*1u' L=lp_min
Minverter_8._28 sel0_L sel0 gnd gnd n W='0.77*1u' L=ln_min
Minverter_8._29 sel0_L sel0 vdd vdd p W='1.54*1u' L=lp_min
.ENDS	$ MMI_MUXI4B
