* FILE: MMI_NOR2B.sp

* SPICE netlist for "MMI_NOR2B" (generated by MMI_SUE4.2.16)

.SUBCKT MMI_NOR2B in0 in1 out
M_0 out in0 gnd gnd n W='0.77*1u' L=ln_min
M_1_1 out in1 gnd gnd n W='0.77*1u' L=ln_min
M_2_1 out in0 net_2 vdd p W='1.54*1u' L=lp_min
M_3_1 out in0 net_1 vdd p W='1.54*1u' L=lp_min
M_4_1 net_2 in1 vdd vdd p W='1.54*1u' L=lp_min
M_5_1 net_1 in1 vdd vdd p W='1.54*1u' L=lp_min
.ENDS	$ MMI_NOR2B
