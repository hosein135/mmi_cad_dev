* FILE: MMI_MUX2C.sp

* SPICE netlist for "MMI_MUX2C" (generated by MMI_SUE4.2.16)

.SUBCKT MMI_MUX2C in0 in1 out sel
Minverter._0 net_2 sel gnd gnd n W='0.385*1u' L=ln_min
Minverter._1 net_2 sel vdd vdd p W='0.77*1u' L=lp_min
Mxgate._2 net_1 sel net_3 vdd p W='1.54*1u' L=lp_min
Mxgate._3 net_1 net_2 net_3 gnd n W='0.77*1u' L=ln_min
Minverter_1._4 net_3 in0 gnd gnd n W='0.77*1u' L=ln_min
Minverter_1._5 net_3 in0 vdd vdd p W='1.54*1u' L=lp_min
Minverter_2._6 net_4 in1 gnd gnd n W='0.77*1u' L=ln_min
Minverter_2._7 net_4 in1 vdd vdd p W='1.54*1u' L=lp_min
Mxgate_1._8 net_1 net_2 net_4 vdd p W='1.54*1u' L=lp_min
Mxgate_1._9 net_1 sel net_4 gnd n W='0.77*1u' L=ln_min
Minverter_3._10 out net_1 gnd gnd n W='1.54*1u' L=ln_min
Minverter_3._11 out net_1 vdd vdd p W='3.08*1u' L=lp_min
.ENDS	$ MMI_MUX2C
