* FILE: MMI_NAND4B.sp

* SPICE netlist for "MMI_NAND4B" (generated by MMI_SUE4.2.16)

.SUBCKT MMI_NAND4B in0 in1 in2 in3 out
M_0 out in0 vdd vdd p W='1.54*1u' L=lp_min
M_1_1 out in1 vdd vdd p W='1.54*1u' L=lp_min
M_2_1 out in2 vdd vdd p W='1.54*1u' L=lp_min
M_3_1 out in3 vdd vdd p W='1.54*1u' L=lp_min
M_4_1 out in0 net_1 gnd n W='3.08*1u' L=ln_min
M_5_1 net_1 in1 net_3 gnd n W='3.08*1u' L=ln_min
M_6_1 net_3 in2 net_2 gnd n W='3.08*1u' L=ln_min
M_7_1 net_2 in3 gnd gnd n W='3.08*1u' L=ln_min
.ENDS	$ MMI_NAND4B
