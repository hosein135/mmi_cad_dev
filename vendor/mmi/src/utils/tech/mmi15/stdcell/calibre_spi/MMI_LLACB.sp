* FILE: MMI_LLACB.sp

* SPICE netlist for "MMI_LLACB" (generated by MMI_SUE4.2.16)

.SUBCKT MMI_LLACB clk clrb d q
Mxgate._0 N2 clk_L N1 vdd p W='1.54*1u' L=lp_min
Mxgate._1 N2 clk N1 gnd n W='0.77*1u' L=ln_min
Minverter._2 N1 d gnd gnd n W='0.77*1u' L=ln_min
Minverter._3 N1 d vdd vdd p W='1.54*1u' L=lp_min
M_4_1 net_2 N5 gnd gnd n W='0.35*1u' L=ln_min
M_5_1 N2 clk net_4 vdd p W='0.35*1u' L=lp_min
M_6_1 net_4 N5 vdd vdd p W='0.35*1u' L=lp_min
M_7_1 N2 clk_L net_2 gnd n W='0.35*1u' L=ln_min
Minverter_1._8 clk_L clk gnd gnd n W='0.385*1u' L=ln_min
Minverter_1._9 clk_L clk vdd vdd p W='0.77*1u' L=lp_min
Minverter_2._10 q net_1 gnd gnd n W='0.77*1u' L=ln_min
Minverter_2._11 q net_1 vdd vdd p W='1.54*1u' L=lp_min
Minverter_3._12 net_1 N5 gnd gnd n W='0.385*1u' L=ln_min
Minverter_3._13 net_1 N5 vdd vdd p W='0.77*1u' L=lp_min
Mnor2._14 N5 N2 gnd gnd n W='0.385*1u' L=ln_min
Mnor2._15 N5 N2 nor2%net_1 vdd p W='1.54*1u' L=lp_min
Mnor2._16 N5 net_3 gnd gnd n W='0.385*1u' L=ln_min
Mnor2._17 nor2%net_1 net_3 vdd vdd p W='1.54*1u' L=lp_min
Minverter_4._18 net_3 clrb gnd gnd n W='0.385*1u' L=ln_min
Minverter_4._19 net_3 clrb vdd vdd p W='0.77*1u' L=lp_min
.ENDS	$ MMI_LLACB
