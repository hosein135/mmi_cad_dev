* FILE: MMI_RPTRF.sp

* SPICE netlist for "MMI_RPTRF" (generated by MMI_SUE4.2.16)

.SUBCKT MMI_RPTRF in out
M_0 out in vdd vdd p W='24.64*1u' L=lp_min
M_1_1 out in gnd gnd n W='12.32*1u' L=ln_min
.ENDS	$ MMI_RPTRF
