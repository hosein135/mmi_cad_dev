* FILE: MMI_AND3B.sp

* SPICE netlist for "MMI_AND3B" (generated by MMI_SUE4.2.16)

.SUBCKT MMI_AND3B in0 in1 in2 out
Minverter1._0 out N1 gnd gnd n W='0.77*1u' L=ln_min
Minverter1._1 out N1 vdd vdd p W='1.54*1u' L=lp_min
M_2_1 N1 in2 vdd vdd p W='0.77*1u' L=lp_min
M_3_1 N1 in1 vdd vdd p W='0.77*1u' L=lp_min
M_4_1 N1 in0 vdd vdd p W='0.77*1u' L=lp_min
M_5_1 N1 in0 net_1 gnd n W='1.155*1u' L=ln_min
M_6_1 net_1 in1 net_2 gnd n W='1.155*1u' L=ln_min
M_7_1 net_2 in2 gnd gnd n W='1.155*1u' L=ln_min
.ENDS	$ MMI_AND3B
