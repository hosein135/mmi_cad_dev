* FILE: MMI_INVB.sp

* SPICE netlist for "MMI_INVB" (generated by MMI_SUE4.2.16)

.SUBCKT MMI_INVB in out
M_0 out in vdd vdd p W='1.54*1u' L=lp_min
M_1_1 out in gnd gnd n W='0.77*1u' L=ln_min
.ENDS	$ MMI_INVB
