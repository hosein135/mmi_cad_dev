* FILE: MMI_AO31C.sp

* SPICE netlist for "MMI_AO31C" (generated by MMI_SUE4.2.16)

.SUBCKT MMI_AO31C in0 in1 in2 in3 out
Minverter1._0 out N1 gnd gnd n W='1.54*1u' L=ln_min
Minverter1._1 out N1 vdd vdd p W='3.08*1u' L=lp_min
M_2_1 N1 in0 gnd gnd n W='0.52*1u' L=ln_min
M_3_1 N1 in1 net_2 gnd n W='1.56*1u' L=ln_min
M_4_1 net_2 in2 net_1 gnd n W='1.56*1u' L=ln_min
M_5_1 net_1 in3 gnd gnd n W='1.56*1u' L=ln_min
M_6_1 N1 in0 net_3 vdd p W='2.08*1u' L=lp_min
M_7_1 net_3 in1 vdd vdd p W='2.08*1u' L=lp_min
M_8_1 net_3 in2 vdd vdd p W='2.08*1u' L=lp_min
M_9_1 net_3 in3 vdd vdd p W='2.08*1u' L=lp_min
.ENDS	$ MMI_AO31C
