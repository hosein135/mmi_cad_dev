* FILE: MMI_FFB.sp

* SPICE netlist for "MMI_FFB" (generated by MMI_SUE4.2.16)

.SUBCKT MMI_FFB clk d q
Minverter._0 q N5 gnd gnd n W='0.77*1u' L=ln_min
Minverter._1 q N5 vdd vdd p W='1.54*1u' L=lp_min
Minverter_1._2 clk_L clk gnd gnd n W='0.385*1u' L=ln_min
Minverter_1._3 clk_L clk vdd vdd p W='0.77*1u' L=lp_min
M_4_1 net_5 N5 gnd gnd n W='0.35*1u' L=ln_min
M_5_1 N4 clk net_3 vdd p W='0.35*1u' L=lp_min
M_6_1 N4 clk_L net_5 gnd n W='0.35*1u' L=ln_min
M_7_1 net_3 N5 vdd vdd p W='0.35*1u' L=lp_min
M_8_1 net_2 N3 vdd vdd p W='0.35*1u' L=lp_min
M_9_1 N2 clk_L net_2 vdd p W='0.35*1u' L=lp_min
M_10_1 N2 clk net_4 gnd n W='0.35*1u' L=ln_min
M_11_1 net_4 N3 gnd gnd n W='0.35*1u' L=ln_min
Mxgate._12 N4 clk_L N3 vdd p W='0.77*1u' L=lp_min
Mxgate._13 N4 clk N3 gnd n W='0.35*1u' L=ln_min
Mxgate_1._14 net_1 clk N2 vdd p W='0.77*1u' L=lp_min
Mxgate_1._15 net_1 clk_L N2 gnd n W='0.35*1u' L=ln_min
Minverter_2._16 N5 N4 gnd gnd n W='0.52*1u' L=ln_min
Minverter_2._17 N5 N4 vdd vdd p W='0.77*1u' L=lp_min
Minverter_3._18 N3 N2 gnd gnd n W='0.385*1u' L=ln_min
Minverter_3._19 N3 N2 vdd vdd p W='0.77*1u' L=lp_min
Minverter_4._20 net_1 d gnd gnd n W='0.385*1u' L=ln_min
Minverter_4._21 net_1 d vdd vdd p W='0.77*1u' L=lp_min
.ic N4=0V
.ENDS	$ MMI_FFB
