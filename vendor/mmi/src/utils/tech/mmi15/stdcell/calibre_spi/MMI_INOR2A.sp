* FILE: MMI_INOR2A.sp

* SPICE netlist for "MMI_INOR2A" (generated by MMI_SUE4.2.16)

.SUBCKT MMI_INOR2A in0 in1 out
Mnor2._0 out in1_L gnd gnd n W='0.385*1u' L=ln_min
Mnor2._1 out in1_L nor2%net_1 vdd p W='1.54*1u' L=lp_min
Mnor2._2 out in0 gnd gnd n W='0.385*1u' L=ln_min
Mnor2._3 nor2%net_1 in0 vdd vdd p W='1.54*1u' L=lp_min
Minverter._4 in1_L in1 gnd gnd n W='0.385*1u' L=ln_min
Minverter._5 in1_L in1 vdd vdd p W='0.77*1u' L=lp_min
.ENDS	$ MMI_INOR2A
