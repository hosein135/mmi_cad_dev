* FILE: MMI_OAI21A.sp

* SPICE netlist for "MMI_OAI21A" (generated by MMI_SUE4.2.16)

.SUBCKT MMI_OAI21A in0 in1 in2 out
M_0 out in0 net_1 gnd n W='0.77*1u' L=ln_min
M_1_1 net_1 in1 gnd gnd n W='0.77*1u' L=ln_min
M_2_1 net_1 in2 gnd gnd n W='0.77*1u' L=ln_min
M_3_1 out in0 vdd vdd p W='0.77*1u' L=lp_min
M_4_1 out in1 net_2 vdd p W='1.54*1u' L=lp_min
M_5_1 net_2 in2 vdd vdd p W='1.54*1u' L=lp_min
.ENDS	$ MMI_OAI21A
