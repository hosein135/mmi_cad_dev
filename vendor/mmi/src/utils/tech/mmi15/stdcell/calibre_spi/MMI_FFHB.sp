* FILE: MMI_FFHB.sp

* SPICE netlist for "MMI_FFHB" (generated by MMI_SUE4.2.16)

.SUBCKT MMI_FFHB clk d hold q
Minverter._0 q N5 gnd gnd n W='0.77*1u' L=ln_min
Minverter._1 q N5 vdd vdd p W='1.54*1u' L=lp_min
M_2_1 net_1 d net_3 vdd p W='1.54*1u' L=lp_min
M_3_1 net_1 d net_2 gnd n W='0.77*1u' L=ln_min
Minverter_1._4 clk_L clk gnd gnd n W='0.385*1u' L=ln_min
Minverter_1._5 clk_L clk vdd vdd p W='0.77*1u' L=lp_min
M_6_1 net_5 N5 gnd gnd n W='0.35*1u' L=ln_min
M_7_1 N4 clk net_4 vdd p W='0.35*1u' L=lp_min
M_8_1 N4 clk_L net_5 gnd n W='0.35*1u' L=ln_min
M_9_1 net_4 N5 vdd vdd p W='0.35*1u' L=lp_min
M_10_1 net_9 N3 vdd vdd p W='0.35*1u' L=lp_min
M_11_1 N2 clk_L net_9 vdd p W='0.35*1u' L=lp_min
M_12_1 N2 clk net_8 gnd n W='0.35*1u' L=ln_min
M_13_1 net_8 N3 gnd gnd n W='0.35*1u' L=ln_min
Mxgate._14 N4 clk_L N3 vdd p W='0.77*1u' L=lp_min
Mxgate._15 N4 clk N3 gnd n W='0.35*1u' L=ln_min
Mxgate_1._16 net_1 clk N2 vdd p W='0.77*1u' L=lp_min
Mxgate_1._17 net_1 clk_L N2 gnd n W='0.35*1u' L=ln_min
Minverter_2._18 N5 N4 gnd gnd n W='0.52*1u' L=ln_min
Minverter_2._19 N5 N4 vdd vdd p W='0.77*1u' L=lp_min
Minverter_3._20 N3 N2 gnd gnd n W='0.385*1u' L=ln_min
Minverter_3._21 N3 N2 vdd vdd p W='0.77*1u' L=lp_min
M_22_1 net_3 hold vdd vdd p W='1.54*1u' L=lp_min
M_23_1 net_1 hold_L net_7 vdd p W='1.54*1u' L=lp_min
M_24_1 net_7 q_fb vdd vdd p W='1.54*1u' L=lp_min
M_25_1 net_2 hold_L gnd gnd n W='0.77*1u' L=ln_min
M_26_1 net_6 hold gnd gnd n W='0.77*1u' L=ln_min
M_27_1 net_1 q_fb net_6 gnd n W='0.77*1u' L=ln_min
Minverter_4._28 q_fb N5 gnd gnd n W='0.385*1u' L=ln_min
Minverter_4._29 q_fb N5 vdd vdd p W='0.77*1u' L=lp_min
Minverter_5._30 hold_L hold gnd gnd n W='0.385*1u' L=ln_min
Minverter_5._31 hold_L hold vdd vdd p W='0.77*1u' L=lp_min
.ic N4=0V
.ENDS	$ MMI_FFHB
