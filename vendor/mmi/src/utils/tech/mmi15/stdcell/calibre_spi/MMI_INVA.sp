* FILE: MMI_INVA.sp

* SPICE netlist for "MMI_INVA" (generated by MMI_SUE4.2.16)

.SUBCKT MMI_INVA in out
M_0 out in vdd vdd p W='0.77*1u' L=lp_min
M_1_1 out in gnd gnd n W='0.385*1u' L=ln_min
.ENDS	$ MMI_INVA
