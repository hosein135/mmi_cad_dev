* FILE: MMI_BUFE.sp

* SPICE netlist for "MMI_BUFE" (generated by MMI_SUE4.2.16)

.SUBCKT MMI_BUFE in out
M_0 out N1 vdd vdd p W='12.32*1u' L=lp_min
M_1_1 out N1 gnd gnd n W='6.16*1u' L=ln_min
M_2_1 N1 in gnd gnd n W='2.08*1u' L=ln_min
M_3_1 N1 in vdd vdd p W='4.16*1u' L=lp_min
.ENDS	$ MMI_BUFE
