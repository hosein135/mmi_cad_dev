* FILE: MMI_AND4C.sp

* SPICE netlist for "MMI_AND4C" (generated by MMI_SUE4.2.16)

.SUBCKT MMI_AND4C in0 in1 in2 in3 out
Minverter1._0 out N1 gnd gnd n W='1.54*1u' L=ln_min
Minverter1._1 out N1 vdd vdd p W='3.08*1u' L=lp_min
M_2_1 N1 in3 vdd vdd p W='1.04*1u' L=lp_min
M_3_1 N1 in2 vdd vdd p W='1.04*1u' L=lp_min
M_4_1 N1 in1 vdd vdd p W='1.04*1u' L=lp_min
M_5_1 N1 in0 vdd vdd p W='1.04*1u' L=lp_min
M_6_1 N1 in0 net_2 gnd n W='1.04*1u' L=ln_min
M_7_1 N1 in0 net_6 gnd n W='1.04*1u' L=ln_min
M_8_1 net_6 in1 net_5 gnd n W='1.04*1u' L=ln_min
M_9_1 net_2 in1 net_1 gnd n W='1.04*1u' L=ln_min
M_10_1 net_5 in2 net_3 gnd n W='1.04*1u' L=ln_min
M_11_1 net_1 in2 net_4 gnd n W='1.04*1u' L=ln_min
M_12_1 net_3 in3 gnd gnd n W='1.04*1u' L=ln_min
M_13_1 net_4 in3 gnd gnd n W='1.04*1u' L=ln_min
.ENDS	$ MMI_AND4C
