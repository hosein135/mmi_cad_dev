* FILE: MMI_mmatch4A.sp

* SPICE netlist for "MMI_mmatch4A" (generated by MMI_SUE4.2.16)

.SUBCKT MMI_mmatch4A in0 in1 in2 in3 mm_out
M_0 net_2 in1 net_5 vdd p W='1.2*1u' L=lp_min
M_1_1 net_2 in0 net_1 gnd n W='0.385*1u' L=ln_min
M_2_1 net_1 in1 gnd gnd n W='0.385*1u' L=ln_min
M_3_1 net_1 in2 gnd gnd n W='0.385*1u' L=ln_min
M_4_1 net_5 in2 net_7 vdd p W='1.2*1u' L=lp_min
M_5_1 net_7 in3 vdd vdd p W='1.2*1u' L=lp_min
M_6_1 net_2 in0 net_5 vdd p W='1.2*1u' L=lp_min
M_7_1 net_2 in2 net_4 vdd p W='1.2*1u' L=lp_min
M_8_1 net_4 in1 net_8 vdd p W='1.2*1u' L=lp_min
M_9_1 net_8 in0 vdd vdd p W='1.2*1u' L=lp_min
M_10_1 net_2 in3 net_4 vdd p W='1.2*1u' L=lp_min
M_11_1 net_2 in1 net_3 gnd n W='0.385*1u' L=ln_min
M_12_1 net_3 in2 gnd gnd n W='0.385*1u' L=ln_min
M_13_1 net_3 in3 gnd gnd n W='0.385*1u' L=ln_min
M_14_1 net_2 in3 net_6 gnd n W='0.385*1u' L=ln_min
M_15_1 net_6 in2 gnd gnd n W='0.385*1u' L=ln_min
M_16_1 net_6 in0 gnd gnd n W='0.385*1u' L=ln_min
M_17_1 mm_out net_2 gnd gnd n W='0.385*1u' L=ln_min
M_18_1 mm_out net_2 vdd vdd p W='0.77*1u' L=lp_min
.ENDS	$ MMI_mmatch4A
