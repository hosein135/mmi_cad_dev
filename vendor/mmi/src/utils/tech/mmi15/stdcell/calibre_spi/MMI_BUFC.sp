* FILE: MMI_BUFC.sp

* SPICE netlist for "MMI_BUFC" (generated by MMI_SUE4.2.16)

.SUBCKT MMI_BUFC in out
M_0 out N1 vdd vdd p W='3.08*1u' L=lp_min
M_1_1 out N1 gnd gnd n W='1.54*1u' L=ln_min
M_2_1 N1 in gnd gnd n W='0.52*1u' L=ln_min
M_3_1 N1 in vdd vdd p W='1.04*1u' L=lp_min
.ENDS	$ MMI_BUFC
