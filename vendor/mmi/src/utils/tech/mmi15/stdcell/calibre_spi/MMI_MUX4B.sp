* FILE: MMI_MUX4B.sp

* SPICE netlist for "MMI_MUX4B" (generated by MMI_SUE4.2.16)

.SUBCKT MMI_MUX4B in0 in1 in2 in3 out sel0 sel1
Mxgate._0 N2 sel1 N1 vdd p W='1.54*1u' L=lp_min
Mxgate._1 N2 sel1_L N1 gnd n W='0.77*1u' L=ln_min
Mxgate_1._2 N2 sel1_L net_5 vdd p W='1.54*1u' L=lp_min
Mxgate_1._3 N2 sel1 net_5 gnd n W='0.77*1u' L=ln_min
Minverter._4 sel1_L sel1 gnd gnd n W='0.385*1u' L=ln_min
Minverter._5 sel1_L sel1 vdd vdd p W='0.77*1u' L=lp_min
Mxgate_2._6 N1 sel0 net_4 vdd p W='1.54*1u' L=lp_min
Mxgate_2._7 N1 net_3 net_4 gnd n W='0.77*1u' L=ln_min
Minverter_1._8 net_4 in0 gnd gnd n W='0.77*1u' L=ln_min
Minverter_1._9 net_4 in0 vdd vdd p W='1.54*1u' L=lp_min
Mxgate_3._10 N1 net_3 net_1 vdd p W='1.54*1u' L=lp_min
Mxgate_3._11 N1 sel0 net_1 gnd n W='0.77*1u' L=ln_min
Minverter_2._12 net_1 in1 gnd gnd n W='0.77*1u' L=ln_min
Minverter_2._13 net_1 in1 vdd vdd p W='1.54*1u' L=lp_min
Mxgate_4._14 net_5 sel0 net_2 vdd p W='1.54*1u' L=lp_min
Mxgate_4._15 net_5 net_3 net_2 gnd n W='0.77*1u' L=ln_min
Minverter_3._16 net_2 in2 gnd gnd n W='0.77*1u' L=ln_min
Minverter_3._17 net_2 in2 vdd vdd p W='1.54*1u' L=lp_min
Mxgate_5._18 net_5 net_3 net_6 vdd p W='1.54*1u' L=lp_min
Mxgate_5._19 net_5 sel0 net_6 gnd n W='0.77*1u' L=ln_min
Minverter_4._20 net_6 in3 gnd gnd n W='0.77*1u' L=ln_min
Minverter_4._21 net_6 in3 vdd vdd p W='1.54*1u' L=lp_min
Minverter_5._22 net_3 sel0 gnd gnd n W='0.52*1u' L=ln_min
Minverter_5._23 net_3 sel0 vdd vdd p W='1.04*1u' L=lp_min
Minverter_6._24 out N2 gnd gnd n W='0.77*1u' L=ln_min
Minverter_6._25 out N2 vdd vdd p W='1.54*1u' L=lp_min
.ENDS	$ MMI_MUX4B
