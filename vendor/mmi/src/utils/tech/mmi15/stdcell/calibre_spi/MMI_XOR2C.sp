* FILE: MMI_XOR2C.sp

* SPICE netlist for "MMI_XOR2C" (generated by MMI_SUE4.2.16)

.SUBCKT MMI_XOR2C in0 in1 out
MMMI_AOI21C._0 out net_1 gnd gnd n W='1.54*1u' L=ln_min
MMMI_AOI21C._1 out in1 MMI_AOI21C%net_1 gnd n W='3.08*1u' L=ln_min
MMMI_AOI21C._2 MMI_AOI21C%net_1 in0 gnd gnd n W='3.08*1u' L=ln_min
MMMI_AOI21C._3 out net_1 MMI_AOI21C%net_2 vdd p W='6.16*1u' L=lp_min
MMMI_AOI21C._4 MMI_AOI21C%net_2 in0 vdd vdd p W='6.16*1u' L=lp_min
MMMI_AOI21C._5 MMI_AOI21C%net_2 in1 vdd vdd p W='6.16*1u' L=lp_min
MMMI_NOR2B._6 net_1 in0 gnd gnd n W='0.77*1u' L=ln_min
MMMI_NOR2B._7 net_1 in1 gnd gnd n W='0.77*1u' L=ln_min
MMMI_NOR2B._8 net_1 in0 MMI_NOR2B%net_2 vdd p W='1.54*1u' L=lp_min
MMMI_NOR2B._9 net_1 in0 MMI_NOR2B%net_1 vdd p W='1.54*1u' L=lp_min
MMMI_NOR2B._10 MMI_NOR2B%net_2 in1 vdd vdd p W='1.54*1u' L=lp_min
MMMI_NOR2B._11 MMI_NOR2B%net_1 in1 vdd vdd p W='1.54*1u' L=lp_min
.ENDS	$ MMI_XOR2C
