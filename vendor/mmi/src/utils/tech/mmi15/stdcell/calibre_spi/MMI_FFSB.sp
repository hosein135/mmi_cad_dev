* FILE: MMI_FFSB.sp

* SPICE netlist for "MMI_FFSB" (generated by MMI_SUE4.2.16)

.SUBCKT MMI_FFSB clk d q setb
Minverter._0 q N5 gnd gnd n W='0.77*1u' L=ln_min
Minverter._1 q N5 vdd vdd p W='1.54*1u' L=lp_min
Minverter_1._2 clk_L clk gnd gnd n W='0.385*1u' L=ln_min
Minverter_1._3 clk_L clk vdd vdd p W='0.77*1u' L=lp_min
M_4_1 net_4 N5 gnd gnd n W='0.35*1u' L=ln_min
M_5_1 N4 clk net_3 vdd p W='0.35*1u' L=lp_min
M_6_1 N4 clk_L net_4 gnd n W='0.35*1u' L=ln_min
M_7_1 net_3 N5 vdd vdd p W='0.35*1u' L=lp_min
M_8_1 net_1 N3 vdd vdd p W='0.35*1u' L=lp_min
M_9_1 N2 clk_L net_1 vdd p W='0.35*1u' L=lp_min
M_10_1 N2 clk net_2 gnd n W='0.35*1u' L=ln_min
M_11_1 net_2 N3 gnd gnd n W='0.35*1u' L=ln_min
Mxgate._12 N4 clk_L N3 vdd p W='0.77*1u' L=lp_min
Mxgate._13 N4 clk N3 gnd n W='0.35*1u' L=ln_min
Mxgate_1._14 N1 clk N2 vdd p W='0.77*1u' L=lp_min
Mxgate_1._15 N1 clk_L N2 gnd n W='0.35*1u' L=ln_min
Mnor2._16 N5 N4 gnd gnd n W='0.52*1u' L=ln_min
Mnor2._17 N5 N4 nor2%net_1 vdd p W='1.54*1u' L=lp_min
Mnor2._18 N5 set gnd gnd n W='0.52*1u' L=ln_min
Mnor2._19 nor2%net_1 set vdd vdd p W='1.54*1u' L=lp_min
Mnand2._20 N3 N2 vdd vdd p W='0.77*1u' L=lp_min
Mnand2._21 N3 N2 nand2%net_1 gnd n W='0.77*1u' L=ln_min
Mnand2._22 N3 setb vdd vdd p W='0.77*1u' L=lp_min
Mnand2._23 nand2%net_1 setb gnd gnd n W='0.77*1u' L=ln_min
* changed sizes on next 2 lines - DW
Minverter_2._24 set setb gnd gnd n W='0.505*1u' L=ln_min
Minverter_2._25 set setb vdd vdd p W='1.005*1u' L=lp_min
*
Minverter_3._26 N1 d gnd gnd n W='0.77*1u' L=ln_min
Minverter_3._27 N1 d vdd vdd p W='1.54*1u' L=lp_min
.ic N4=0V
.ENDS	$ MMI_FFSB
