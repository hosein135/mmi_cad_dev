* FILE: MMI_INAND2C.sp

* SPICE netlist for "MMI_INAND2C" (generated by MMI_SUE4.2.16)

.SUBCKT MMI_INAND2C in0 in1 out
M_0 out in1_L vdd vdd p W='3.08*1u' L=lp_min
M_1_1 out in0 vdd vdd p W='3.08*1u' L=lp_min
M_2_1 out in1_L net_1 gnd n W='1.54*1u' L=ln_min
M_3_1 out in1_L net_2 gnd n W='1.54*1u' L=ln_min
M_4_1 net_2 in0 gnd gnd n W='1.54*1u' L=ln_min
M_5_1 net_1 in0 gnd gnd n W='1.54*1u' L=ln_min
Minverter._6 in1_L in1 gnd gnd n W='0.77*1u' L=ln_min
Minverter._7 in1_L in1 vdd vdd p W='1.54*1u' L=lp_min
.ENDS	$ MMI_INAND2C
