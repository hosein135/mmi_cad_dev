* FILE: MMI_INVE.sp

* SPICE netlist for "MMI_INVE" (generated by MMI_SUE4.2.16)

.SUBCKT MMI_INVE in out
M_0 out in gnd gnd n W='6.16*1u' L=ln_min
M_1_1 out in vdd vdd p W='12.32*1u' L=lp_min
.ENDS	$ MMI_INVE
