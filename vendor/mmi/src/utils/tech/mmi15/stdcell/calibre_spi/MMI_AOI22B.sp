* FILE: MMI_AOI22B.sp

* SPICE netlist for "MMI_AOI22B" (generated by MMI_SUE4.2.16)

.SUBCKT MMI_AOI22B in0 in1 in2 in3 out
M_0 out in0 net_3 gnd n W='0.77*1u' L=ln_min
M_1_1 out in0 net_4 gnd n W='0.77*1u' L=ln_min
M_2_1 net_4 in1 gnd gnd n W='0.77*1u' L=ln_min
M_3_1 net_3 in1 gnd gnd n W='0.77*1u' L=ln_min
M_4_1 net_2 in3 gnd gnd n W='0.77*1u' L=ln_min
M_5_1 net_5 in3 gnd gnd n W='0.77*1u' L=ln_min
M_6_1 out in2 net_5 gnd n W='0.77*1u' L=ln_min
M_7_1 out in2 net_2 gnd n W='0.77*1u' L=ln_min
M_8_1 out in0 net_1 vdd p W='1.54*1u' L=lp_min
M_9_1 out in0 net_1 vdd p W='1.54*1u' L=lp_min
M_10_1 net_1 in2 vdd vdd p W='1.54*1u' L=lp_min
M_11_1 net_1 in2 vdd vdd p W='1.54*1u' L=lp_min
M_12_1 out in1 net_1 vdd p W='1.54*1u' L=lp_min
M_13_1 out in1 net_1 vdd p W='1.54*1u' L=lp_min
M_14_1 net_1 in3 vdd vdd p W='1.54*1u' L=lp_min
M_15_1 net_1 in3 vdd vdd p W='1.54*1u' L=lp_min
.ENDS	$ MMI_AOI22B
