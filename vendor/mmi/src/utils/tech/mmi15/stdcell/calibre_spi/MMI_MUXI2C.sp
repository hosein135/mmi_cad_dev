* FILE: MMI_MUXI2C.sp

* SPICE netlist for "MMI_MUXI2C" (generated by MMI_SUE4.2.16)

.SUBCKT MMI_MUXI2C in0 in1 out sel
Mxgate._0 out sel net_2 vdd p W='6.16*1u' L=lp_min
Mxgate._1 out net_1 net_2 gnd n W='3.08*1u' L=ln_min
Minverter._2 net_2 in0 gnd gnd n W='3.08*1u' L=ln_min
Minverter._3 net_2 in0 vdd vdd p W='6.16*1u' L=lp_min
Minverter_1._4 net_3 in1 gnd gnd n W='3.08*1u' L=ln_min
Minverter_1._5 net_3 in1 vdd vdd p W='6.16*1u' L=lp_min
Mxgate_1._6 out net_1 net_3 vdd p W='6.16*1u' L=lp_min
Mxgate_1._7 out sel net_3 gnd n W='3.08*1u' L=ln_min
Minverter_2._8 net_1 sel gnd gnd n W='0.77*1u' L=ln_min
Minverter_2._9 net_1 sel vdd vdd p W='1.54*1u' L=lp_min
.ENDS	$ MMI_MUXI2C
