* FILE: MMI_INVD.sp

* SPICE netlist for "MMI_INVD" (generated by MMI_SUE4.2.16)

.SUBCKT MMI_INVD in out
M_0 out in gnd gnd n W='3.08*1u' L=ln_min
M_1_1 out in vdd vdd p W='6.16*1u' L=lp_min
.ENDS	$ MMI_INVD
