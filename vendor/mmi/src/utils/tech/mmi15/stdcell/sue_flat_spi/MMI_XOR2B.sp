* FILE: MMI_XOR2B.sp

* SPICE netlist for "MMI_XOR2B" (generated by MMI_SUE4.2.16)

*.SUBCKT MMI_XOR2B in0 in1 out
MMMI_NOR2A._0 net_1 in0 gnd gnd n W='0.385*1u' L=ln_min
+ ad='arean(0.385,sdd)' as='arean(0.385,sdd)' pd='perin(0.385,sdd)'
+ ps='perin(0.385,sdd)'
MMMI_NOR2A._1 net_1 in1 gnd gnd n W='0.385*1u' L=ln_min
+ ad='arean(0.385,sdd)' as='arean(0.385,sdd)' pd='perin(0.385,sdd)'
+ ps='perin(0.385,sdd)'
MMMI_NOR2A._2 net_1 in0 MMI_NOR2A%net_1 vdd p W='1.54*1u' L=lp_min
+ ad='areap(1.54,sdd)' as='areap(1.54,sdd)' pd='perip(1.54,sdd)'
+ ps='perip(1.54,sdd)'
MMMI_NOR2A._3 MMI_NOR2A%net_1 in1 vdd vdd p W='1.54*1u' L=lp_min
+ ad='areap(1.54,sdd)' as='areap(1.54,sdd)' pd='perip(1.54,sdd)'
+ ps='perip(1.54,sdd)'
MMMI_AOI21B._4 out net_1 gnd gnd n W='0.77*1u' L=ln_min
+ ad='arean(0.77,sdd)' as='arean(0.77,sdd)' pd='perin(0.77,sdd)'
+ ps='perin(0.77,sdd)'
MMMI_AOI21B._5 out in1 MMI_AOI21B%net_1 gnd n W='1.54*1u' L=ln_min
+ ad='arean(1.54,sdd)' as='arean(1.54,sdd)' pd='perin(1.54,sdd)'
+ ps='perin(1.54,sdd)'
MMMI_AOI21B._6 MMI_AOI21B%net_1 in0 gnd gnd n W='1.54*1u' L=ln_min
+ ad='arean(1.54,sdd)' as='arean(1.54,sdd)' pd='perin(1.54,sdd)'
+ ps='perin(1.54,sdd)'
MMMI_AOI21B._7 out net_1 MMI_AOI21B%net_2 vdd p W='3.08*1u' L=lp_min
+ ad='areap(3.08,sdd)' as='areap(3.08,sdd)' pd='perip(3.08,sdd)'
+ ps='perip(3.08,sdd)'
MMMI_AOI21B._8 MMI_AOI21B%net_2 in0 vdd vdd p W='3.08*1u' L=lp_min
+ ad='areap(3.08,sdd)' as='areap(3.08,sdd)' pd='perip(3.08,sdd)'
+ ps='perip(3.08,sdd)'
MMMI_AOI21B._9 MMI_AOI21B%net_2 in1 vdd vdd p W='3.08*1u' L=lp_min
+ ad='areap(3.08,sdd)' as='areap(3.08,sdd)' pd='perip(3.08,sdd)'
+ ps='perip(3.08,sdd)'
*.ENDS	$ MMI_XOR2B
