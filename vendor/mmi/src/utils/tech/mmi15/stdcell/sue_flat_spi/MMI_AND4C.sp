* FILE: MMI_AND4C.sp

* SPICE netlist for "MMI_AND4C" (generated by MMI_SUE4.2.16)

*.SUBCKT MMI_AND4C in0 in1 in2 in3 out
Minverter1._0 out N1 gnd gnd n W='1.54*1u' L=ln_min ad='arean(1.54,sdd)'
+ as='arean(1.54,sdd)' pd='perin(1.54,sdd)' ps='perin(1.54,sdd)'
Minverter1._1 out N1 vdd vdd p W='3.08*1u' L=lp_min ad='areap(3.08,sdd)'
+ as='areap(3.08,sdd)' pd='perip(3.08,sdd)' ps='perip(3.08,sdd)'
M_2_1 N1 in3 vdd vdd p W='1.04*1u' L=lp_min ad='areap(1.04,sdd)'
+ as='areap(1.04,sdd)' pd='perip(1.04,sdd)' ps='perip(1.04,sdd)'
M_3_1 N1 in2 vdd vdd p W='1.04*1u' L=lp_min ad='areap(1.04,sdd)'
+ as='areap(1.04,sdd)' pd='perip(1.04,sdd)' ps='perip(1.04,sdd)'
M_4_1 N1 in1 vdd vdd p W='1.04*1u' L=lp_min ad='areap(1.04,sdd)'
+ as='areap(1.04,sdd)' pd='perip(1.04,sdd)' ps='perip(1.04,sdd)'
M_5_1 N1 in0 vdd vdd p W='1.04*1u' L=lp_min ad='areap(1.04,sdd)'
+ as='areap(1.04,sdd)' pd='perip(1.04,sdd)' ps='perip(1.04,sdd)'
M_6_1 N1 in0 net_2 gnd n W='1.04*1u' L=ln_min ad='arean(1.04,sdd)'
+ as='arean(1.04,sdd)' pd='perin(1.04,sdd)' ps='perin(1.04,sdd)'
M_7_1 N1 in0 net_6 gnd n W='1.04*1u' L=ln_min ad='arean(1.04,sdd)'
+ as='arean(1.04,sdd)' pd='perin(1.04,sdd)' ps='perin(1.04,sdd)'
M_8_1 net_6 in1 net_5 gnd n W='1.04*1u' L=ln_min ad='arean(1.04,sdd)'
+ as='arean(1.04,sdd)' pd='perin(1.04,sdd)' ps='perin(1.04,sdd)'
M_9_1 net_2 in1 net_1 gnd n W='1.04*1u' L=ln_min ad='arean(1.04,sdd)'
+ as='arean(1.04,sdd)' pd='perin(1.04,sdd)' ps='perin(1.04,sdd)'
M_10_1 net_5 in2 net_3 gnd n W='1.04*1u' L=ln_min ad='arean(1.04,sdd)'
+ as='arean(1.04,sdd)' pd='perin(1.04,sdd)' ps='perin(1.04,sdd)'
M_11_1 net_1 in2 net_4 gnd n W='1.04*1u' L=ln_min ad='arean(1.04,sdd)'
+ as='arean(1.04,sdd)' pd='perin(1.04,sdd)' ps='perin(1.04,sdd)'
M_12_1 net_3 in3 gnd gnd n W='1.04*1u' L=ln_min ad='arean(1.04,sdd)'
+ as='arean(1.04,sdd)' pd='perin(1.04,sdd)' ps='perin(1.04,sdd)'
M_13_1 net_4 in3 gnd gnd n W='1.04*1u' L=ln_min ad='arean(1.04,sdd)'
+ as='arean(1.04,sdd)' pd='perin(1.04,sdd)' ps='perin(1.04,sdd)'
*.ENDS	$ MMI_AND4C
