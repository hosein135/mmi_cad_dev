* FILE: MMI_MUX2D.sp

* SPICE netlist for "MMI_MUX2D" (generated by MMI_SUE4.2.16)

*.SUBCKT MMI_MUX2D in0 in1 out sel
Mxgate._0 net_2 sel net_4 vdd p W='3.08*1u' L=lp_min ad='areap(3.08,sdd)'
+ as='areap(3.08,sdd)' pd='perip(3.08,sdd)' ps='perip(3.08,sdd)'
Mxgate._1 net_2 net_1 net_4 gnd n W='1.54*1u' L=ln_min ad='arean(1.54,sdd)'
+ as='arean(1.54,sdd)' pd='perin(1.54,sdd)' ps='perin(1.54,sdd)'
Minverter._2 net_4 in0 gnd gnd n W='1.54*1u' L=ln_min ad='arean(1.54,sdd)'
+ as='arean(1.54,sdd)' pd='perin(1.54,sdd)' ps='perin(1.54,sdd)'
Minverter._3 net_4 in0 vdd vdd p W='3.08*1u' L=lp_min ad='areap(3.08,sdd)'
+ as='areap(3.08,sdd)' pd='perip(3.08,sdd)' ps='perip(3.08,sdd)'
Minverter_1._4 net_3 in1 gnd gnd n W='1.54*1u' L=ln_min
+ ad='arean(1.54,sdd)' as='arean(1.54,sdd)' pd='perin(1.54,sdd)'
+ ps='perin(1.54,sdd)'
Minverter_1._5 net_3 in1 vdd vdd p W='3.08*1u' L=lp_min
+ ad='areap(3.08,sdd)' as='areap(3.08,sdd)' pd='perip(3.08,sdd)'
+ ps='perip(3.08,sdd)'
Mxgate_1._6 net_2 net_1 net_3 vdd p W='3.08*1u' L=lp_min
+ ad='areap(3.08,sdd)' as='areap(3.08,sdd)' pd='perip(3.08,sdd)'
+ ps='perip(3.08,sdd)'
Mxgate_1._7 net_2 sel net_3 gnd n W='1.54*1u' L=ln_min ad='arean(1.54,sdd)'
+ as='arean(1.54,sdd)' pd='perin(1.54,sdd)' ps='perin(1.54,sdd)'
Minverter_2._8 net_1 sel gnd gnd n W='0.52*1u' L=ln_min
+ ad='arean(0.52,sdd)' as='arean(0.52,sdd)' pd='perin(0.52,sdd)'
+ ps='perin(0.52,sdd)'
Minverter_2._9 net_1 sel vdd vdd p W='1.04*1u' L=lp_min
+ ad='areap(1.04,sdd)' as='areap(1.04,sdd)' pd='perip(1.04,sdd)'
+ ps='perip(1.04,sdd)'
Minverter_3._10 out net_2 gnd gnd n W='3.08*1u' L=ln_min
+ ad='arean(3.08,sdd)' as='arean(3.08,sdd)' pd='perin(3.08,sdd)'
+ ps='perin(3.08,sdd)'
Minverter_3._11 out net_2 vdd vdd p W='6.16*1u' L=lp_min
+ ad='areap(6.16,sdd)' as='areap(6.16,sdd)' pd='perip(6.16,sdd)'
+ ps='perip(6.16,sdd)'
*.ENDS	$ MMI_MUX2D
