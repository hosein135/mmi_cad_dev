* FILE: MMI_MUX2C.sp

* SPICE netlist for "MMI_MUX2C" (generated by MMI_SUE4.2.16)

*.SUBCKT MMI_MUX2C in0 in1 out sel
Minverter._0 net_2 sel gnd gnd n W='0.385*1u' L=ln_min
+ ad='arean(0.385,sdd)' as='arean(0.385,sdd)' pd='perin(0.385,sdd)'
+ ps='perin(0.385,sdd)'
Minverter._1 net_2 sel vdd vdd p W='0.77*1u' L=lp_min ad='areap(0.77,sdd)'
+ as='areap(0.77,sdd)' pd='perip(0.77,sdd)' ps='perip(0.77,sdd)'
Mxgate._2 net_1 sel net_3 vdd p W='1.54*1u' L=lp_min ad='areap(1.54,sdd)'
+ as='areap(1.54,sdd)' pd='perip(1.54,sdd)' ps='perip(1.54,sdd)'
Mxgate._3 net_1 net_2 net_3 gnd n W='0.77*1u' L=ln_min ad='arean(0.77,sdd)'
+ as='arean(0.77,sdd)' pd='perin(0.77,sdd)' ps='perin(0.77,sdd)'
Minverter_1._4 net_3 in0 gnd gnd n W='0.77*1u' L=ln_min
+ ad='arean(0.77,sdd)' as='arean(0.77,sdd)' pd='perin(0.77,sdd)'
+ ps='perin(0.77,sdd)'
Minverter_1._5 net_3 in0 vdd vdd p W='1.54*1u' L=lp_min
+ ad='areap(1.54,sdd)' as='areap(1.54,sdd)' pd='perip(1.54,sdd)'
+ ps='perip(1.54,sdd)'
Minverter_2._6 net_4 in1 gnd gnd n W='0.77*1u' L=ln_min
+ ad='arean(0.77,sdd)' as='arean(0.77,sdd)' pd='perin(0.77,sdd)'
+ ps='perin(0.77,sdd)'
Minverter_2._7 net_4 in1 vdd vdd p W='1.54*1u' L=lp_min
+ ad='areap(1.54,sdd)' as='areap(1.54,sdd)' pd='perip(1.54,sdd)'
+ ps='perip(1.54,sdd)'
Mxgate_1._8 net_1 net_2 net_4 vdd p W='1.54*1u' L=lp_min
+ ad='areap(1.54,sdd)' as='areap(1.54,sdd)' pd='perip(1.54,sdd)'
+ ps='perip(1.54,sdd)'
Mxgate_1._9 net_1 sel net_4 gnd n W='0.77*1u' L=ln_min ad='arean(0.77,sdd)'
+ as='arean(0.77,sdd)' pd='perin(0.77,sdd)' ps='perin(0.77,sdd)'
Minverter_3._10 out net_1 gnd gnd n W='1.54*1u' L=ln_min
+ ad='arean(1.54,sdd)' as='arean(1.54,sdd)' pd='perin(1.54,sdd)'
+ ps='perin(1.54,sdd)'
Minverter_3._11 out net_1 vdd vdd p W='3.08*1u' L=lp_min
+ ad='areap(3.08,sdd)' as='areap(3.08,sdd)' pd='perip(3.08,sdd)'
+ ps='perip(3.08,sdd)'
*.ENDS	$ MMI_MUX2C
