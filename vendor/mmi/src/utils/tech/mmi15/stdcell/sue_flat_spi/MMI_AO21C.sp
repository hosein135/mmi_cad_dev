* FILE: MMI_AO21C.sp

* SPICE netlist for "MMI_AO21C" (generated by MMI_SUE4.2.16)

*.SUBCKT MMI_AO21C in0 in1 in2 out
Minverter1._0 out N1 gnd gnd n W='1.54*1u' L=ln_min ad='arean(1.54,sdd)'
+ as='arean(1.54,sdd)' pd='perin(1.54,sdd)' ps='perin(1.54,sdd)'
Minverter1._1 out N1 vdd vdd p W='3.08*1u' L=lp_min ad='areap(3.08,sdd)'
+ as='areap(3.08,sdd)' pd='perip(3.08,sdd)' ps='perip(3.08,sdd)'
M_2_1 N1 in0 gnd gnd n W='0.52*1u' L=ln_min ad='arean(0.52,sdd)'
+ as='arean(0.52,sdd)' pd='perin(0.52,sdd)' ps='perin(0.52,sdd)'
M_3_1 N1 in1 net_1 gnd n W='1.04*1u' L=ln_min ad='arean(1.04,sdd)'
+ as='arean(1.04,sdd)' pd='perin(1.04,sdd)' ps='perin(1.04,sdd)'
M_4_1 net_1 in2 gnd gnd n W='1.04*1u' L=ln_min ad='arean(1.04,sdd)'
+ as='arean(1.04,sdd)' pd='perin(1.04,sdd)' ps='perin(1.04,sdd)'
M_5_1 N1 in0 net_2 vdd p W='2.08*1u' L=lp_min ad='areap(2.08,sdd)'
+ as='areap(2.08,sdd)' pd='perip(2.08,sdd)' ps='perip(2.08,sdd)'
M_6_1 net_2 in2 vdd vdd p W='2.08*1u' L=lp_min ad='areap(2.08,sdd)'
+ as='areap(2.08,sdd)' pd='perip(2.08,sdd)' ps='perip(2.08,sdd)'
M_7_1 net_2 in1 vdd vdd p W='2.08*1u' L=lp_min ad='areap(2.08,sdd)'
+ as='areap(2.08,sdd)' pd='perip(2.08,sdd)' ps='perip(2.08,sdd)'
*.ENDS	$ MMI_AO21C
