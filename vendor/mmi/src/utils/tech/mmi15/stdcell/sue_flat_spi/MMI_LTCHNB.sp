* FILE: MMI_LTCHNB.sp

* SPICE netlist for "MMI_LTCHNB" (generated by MMI_SUE4.2.16)

*.SUBCKT MMI_LTCHNB clk d q
Minverter._0 N1 d gnd gnd n W='0.77*1u' L=ln_min ad='arean(0.77,sdd)'
+ as='arean(0.77,sdd)' pd='perin(0.77,sdd)' ps='perin(0.77,sdd)'
Minverter._1 N1 d vdd vdd p W='1.54*1u' L=lp_min ad='areap(1.54,sdd)'
+ as='areap(1.54,sdd)' pd='perip(1.54,sdd)' ps='perip(1.54,sdd)'
M_2_1 net_1 N5 gnd gnd n W='0.35*1u' L=ln_min ad='arean(0.35,sdd)'
+ as='arean(0.35,sdd)' pd='perin(0.35,sdd)' ps='perin(0.35,sdd)'
M_3_1 N2 clk_L net_2 vdd p W='0.35*1u' L=lp_min ad='areap(0.35,sdd)'
+ as='areap(0.35,sdd)' pd='perip(0.35,sdd)' ps='perip(0.35,sdd)'
M_4_1 net_2 N5 vdd vdd p W='0.35*1u' L=lp_min ad='areap(0.35,sdd)'
+ as='areap(0.35,sdd)' pd='perip(0.35,sdd)' ps='perip(0.35,sdd)'
M_5_1 N2 clk net_1 gnd n W='0.35*1u' L=ln_min ad='arean(0.35,sdd)'
+ as='arean(0.35,sdd)' pd='perin(0.35,sdd)' ps='perin(0.35,sdd)'
Minverter_1._6 clk_L clk gnd gnd n W='0.385*1u' L=ln_min
+ ad='arean(0.385,sdd)' as='arean(0.385,sdd)' pd='perin(0.385,sdd)'
+ ps='perin(0.385,sdd)'
Minverter_1._7 clk_L clk vdd vdd p W='0.77*1u' L=lp_min
+ ad='areap(0.77,sdd)' as='areap(0.77,sdd)' pd='perip(0.77,sdd)'
+ ps='perip(0.77,sdd)'
Minverter_2._8 q N2 gnd gnd n W='0.77*1u' L=ln_min ad='arean(0.77,sdd)'
+ as='arean(0.77,sdd)' pd='perin(0.77,sdd)' ps='perin(0.77,sdd)'
Minverter_2._9 q N2 vdd vdd p W='1.54*1u' L=lp_min ad='areap(1.54,sdd)'
+ as='areap(1.54,sdd)' pd='perip(1.54,sdd)' ps='perip(1.54,sdd)'
Minverter_3._10 N5 N2 gnd gnd n W='0.385*1u' L=ln_min ad='arean(0.385,sdd)'
+ as='arean(0.385,sdd)' pd='perin(0.385,sdd)' ps='perin(0.385,sdd)'
Minverter_3._11 N5 N2 vdd vdd p W='0.77*1u' L=lp_min ad='areap(0.77,sdd)'
+ as='areap(0.77,sdd)' pd='perip(0.77,sdd)' ps='perip(0.77,sdd)'
Mxgate._12 N2 clk N1 vdd p W='1.54*1u' L=lp_min ad='areap(1.54,sdd)'
+ as='areap(1.54,sdd)' pd='perip(1.54,sdd)' ps='perip(1.54,sdd)'
Mxgate._13 N2 clk_L N1 gnd n W='0.77*1u' L=ln_min ad='arean(0.77,sdd)'
+ as='arean(0.77,sdd)' pd='perin(0.77,sdd)' ps='perin(0.77,sdd)'
*.ENDS	$ MMI_LTCHNB
