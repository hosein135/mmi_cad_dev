* FILE: MMI_NAND3A.sp

* SPICE netlist for "MMI_NAND3A" (generated by MMI_SUE4.2.16)

*.SUBCKT MMI_NAND3A in0 in1 in2 out
M_0 out in0 net_1 gnd n W='1.155*1u' L=ln_min ad='arean(1.155,sdd)'
+ as='arean(1.155,sdd)' pd='perin(1.155,sdd)' ps='perin(1.155,sdd)'
M_1_1 net_1 in1 net_2 gnd n W='1.155*1u' L=ln_min ad='arean(1.155,sdd)'
+ as='arean(1.155,sdd)' pd='perin(1.155,sdd)' ps='perin(1.155,sdd)'
M_2_1 net_2 in2 gnd gnd n W='1.155*1u' L=ln_min ad='arean(1.155,sdd)'
+ as='arean(1.155,sdd)' pd='perin(1.155,sdd)' ps='perin(1.155,sdd)'
M_3_1 out in0 vdd vdd p W='0.77*1u' L=lp_min ad='areap(0.77,sdd)'
+ as='areap(0.77,sdd)' pd='perip(0.77,sdd)' ps='perip(0.77,sdd)'
M_4_1 out in1 vdd vdd p W='0.77*1u' L=lp_min ad='areap(0.77,sdd)'
+ as='areap(0.77,sdd)' pd='perip(0.77,sdd)' ps='perip(0.77,sdd)'
M_5_1 out in2 vdd vdd p W='0.77*1u' L=lp_min ad='areap(0.77,sdd)'
+ as='areap(0.77,sdd)' pd='perip(0.77,sdd)' ps='perip(0.77,sdd)'
*.ENDS	$ MMI_NAND3A
