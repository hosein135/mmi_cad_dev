* FILE: MMI_XOR2C.sp

* SPICE netlist for "MMI_XOR2C" (generated by MMI_SUE4.2.16)

*.SUBCKT MMI_XOR2C in0 in1 out
MMMI_AOI21C._0 out net_1 gnd gnd n W='1.54*1u' L=ln_min
+ ad='arean(1.54,sdd)' as='arean(1.54,sdd)' pd='perin(1.54,sdd)'
+ ps='perin(1.54,sdd)'
MMMI_AOI21C._1 out in1 MMI_AOI21C%net_1 gnd n W='3.08*1u' L=ln_min
+ ad='arean(3.08,sdd)' as='arean(3.08,sdd)' pd='perin(3.08,sdd)'
+ ps='perin(3.08,sdd)'
MMMI_AOI21C._2 MMI_AOI21C%net_1 in0 gnd gnd n W='3.08*1u' L=ln_min
+ ad='arean(3.08,sdd)' as='arean(3.08,sdd)' pd='perin(3.08,sdd)'
+ ps='perin(3.08,sdd)'
MMMI_AOI21C._3 out net_1 MMI_AOI21C%net_2 vdd p W='6.16*1u' L=lp_min
+ ad='areap(6.16,sdd)' as='areap(6.16,sdd)' pd='perip(6.16,sdd)'
+ ps='perip(6.16,sdd)'
MMMI_AOI21C._4 MMI_AOI21C%net_2 in0 vdd vdd p W='6.16*1u' L=lp_min
+ ad='areap(6.16,sdd)' as='areap(6.16,sdd)' pd='perip(6.16,sdd)'
+ ps='perip(6.16,sdd)'
MMMI_AOI21C._5 MMI_AOI21C%net_2 in1 vdd vdd p W='6.16*1u' L=lp_min
+ ad='areap(6.16,sdd)' as='areap(6.16,sdd)' pd='perip(6.16,sdd)'
+ ps='perip(6.16,sdd)'
MMMI_NOR2B._6 net_1 in0 gnd gnd n W='0.77*1u' L=ln_min ad='arean(0.77,sdd)'
+ as='arean(0.77,sdd)' pd='perin(0.77,sdd)' ps='perin(0.77,sdd)'
MMMI_NOR2B._7 net_1 in1 gnd gnd n W='0.77*1u' L=ln_min ad='arean(0.77,sdd)'
+ as='arean(0.77,sdd)' pd='perin(0.77,sdd)' ps='perin(0.77,sdd)'
MMMI_NOR2B._8 net_1 in0 MMI_NOR2B%net_2 vdd p W='1.54*1u' L=lp_min
+ ad='areap(1.54,sdd)' as='areap(1.54,sdd)' pd='perip(1.54,sdd)'
+ ps='perip(1.54,sdd)'
MMMI_NOR2B._9 net_1 in0 MMI_NOR2B%net_1 vdd p W='1.54*1u' L=lp_min
+ ad='areap(1.54,sdd)' as='areap(1.54,sdd)' pd='perip(1.54,sdd)'
+ ps='perip(1.54,sdd)'
MMMI_NOR2B._10 MMI_NOR2B%net_2 in1 vdd vdd p W='1.54*1u' L=lp_min
+ ad='areap(1.54,sdd)' as='areap(1.54,sdd)' pd='perip(1.54,sdd)'
+ ps='perip(1.54,sdd)'
MMMI_NOR2B._11 MMI_NOR2B%net_1 in1 vdd vdd p W='1.54*1u' L=lp_min
+ ad='areap(1.54,sdd)' as='areap(1.54,sdd)' pd='perip(1.54,sdd)'
+ ps='perip(1.54,sdd)'
*.ENDS	$ MMI_XOR2C
