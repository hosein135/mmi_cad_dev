* FILE: MMI_NAND4B.sp

* SPICE netlist for "MMI_NAND4B" (generated by MMI_SUE4.2.16)

*.SUBCKT MMI_NAND4B in0 in1 in2 in3 out
M_0 out in0 vdd vdd p W='1.54*1u' L=lp_min ad='areap(1.54,sdd)'
+ as='areap(1.54,sdd)' pd='perip(1.54,sdd)' ps='perip(1.54,sdd)'
M_1_1 out in1 vdd vdd p W='1.54*1u' L=lp_min ad='areap(1.54,sdd)'
+ as='areap(1.54,sdd)' pd='perip(1.54,sdd)' ps='perip(1.54,sdd)'
M_2_1 out in2 vdd vdd p W='1.54*1u' L=lp_min ad='areap(1.54,sdd)'
+ as='areap(1.54,sdd)' pd='perip(1.54,sdd)' ps='perip(1.54,sdd)'
M_3_1 out in3 vdd vdd p W='1.54*1u' L=lp_min ad='areap(1.54,sdd)'
+ as='areap(1.54,sdd)' pd='perip(1.54,sdd)' ps='perip(1.54,sdd)'
M_4_1 out in0 net_1 gnd n W='3.08*1u' L=ln_min ad='arean(3.08,sdd)'
+ as='arean(3.08,sdd)' pd='perin(3.08,sdd)' ps='perin(3.08,sdd)'
M_5_1 net_1 in1 net_3 gnd n W='3.08*1u' L=ln_min ad='arean(3.08,sdd)'
+ as='arean(3.08,sdd)' pd='perin(3.08,sdd)' ps='perin(3.08,sdd)'
M_6_1 net_3 in2 net_2 gnd n W='3.08*1u' L=ln_min ad='arean(3.08,sdd)'
+ as='arean(3.08,sdd)' pd='perin(3.08,sdd)' ps='perin(3.08,sdd)'
M_7_1 net_2 in3 gnd gnd n W='3.08*1u' L=ln_min ad='arean(3.08,sdd)'
+ as='arean(3.08,sdd)' pd='perin(3.08,sdd)' ps='perin(3.08,sdd)'
*.ENDS	$ MMI_NAND4B
