* FILE: MMI_MUXI3B.sp

* SPICE netlist for "MMI_MUXI3B" (generated by MMI_SUE4.2.16)

*.SUBCKT MMI_MUXI3B in0 in1 in2 out sel0 sel1
Mxgate._0 N2 sel1 N1 vdd p W='1.54*1u' L=lp_min ad='areap(1.54,sdd)'
+ as='areap(1.54,sdd)' pd='perip(1.54,sdd)' ps='perip(1.54,sdd)'
Mxgate._1 N2 sel1_L N1 gnd n W='0.77*1u' L=ln_min ad='arean(0.77,sdd)'
+ as='arean(0.77,sdd)' pd='perin(0.77,sdd)' ps='perin(0.77,sdd)'
Mxgate_1._2 N2 sel1_L in2_L vdd p W='1.54*1u' L=lp_min ad='areap(1.54,sdd)'
+ as='areap(1.54,sdd)' pd='perip(1.54,sdd)' ps='perip(1.54,sdd)'
Mxgate_1._3 N2 sel1 in2_L gnd n W='0.77*1u' L=ln_min ad='arean(0.77,sdd)'
+ as='arean(0.77,sdd)' pd='perin(0.77,sdd)' ps='perin(0.77,sdd)'
Minverter._4 in2_L net_5 gnd gnd n W='0.77*1u' L=ln_min
+ ad='arean(0.77,sdd)' as='arean(0.77,sdd)' pd='perin(0.77,sdd)'
+ ps='perin(0.77,sdd)'
Minverter._5 in2_L net_5 vdd vdd p W='1.54*1u' L=lp_min
+ ad='areap(1.54,sdd)' as='areap(1.54,sdd)' pd='perip(1.54,sdd)'
+ ps='perip(1.54,sdd)'
Minverter_1._6 sel1_L sel1 gnd gnd n W='0.385*1u' L=ln_min
+ ad='arean(0.385,sdd)' as='arean(0.385,sdd)' pd='perin(0.385,sdd)'
+ ps='perin(0.385,sdd)'
Minverter_1._7 sel1_L sel1 vdd vdd p W='0.77*1u' L=lp_min
+ ad='areap(0.77,sdd)' as='areap(0.77,sdd)' pd='perip(0.77,sdd)'
+ ps='perip(0.77,sdd)'
Mxgate_2._8 net_1 sel0 net_3 vdd p W='1.54*1u' L=lp_min
+ ad='areap(1.54,sdd)' as='areap(1.54,sdd)' pd='perip(1.54,sdd)'
+ ps='perip(1.54,sdd)'
Mxgate_2._9 net_1 net_4 net_3 gnd n W='0.77*1u' L=ln_min
+ ad='arean(0.77,sdd)' as='arean(0.77,sdd)' pd='perin(0.77,sdd)'
+ ps='perin(0.77,sdd)'
Minverter_2._10 net_3 in0 gnd gnd n W='0.77*1u' L=ln_min
+ ad='arean(0.77,sdd)' as='arean(0.77,sdd)' pd='perin(0.77,sdd)'
+ ps='perin(0.77,sdd)'
Minverter_2._11 net_3 in0 vdd vdd p W='1.54*1u' L=lp_min
+ ad='areap(1.54,sdd)' as='areap(1.54,sdd)' pd='perip(1.54,sdd)'
+ ps='perip(1.54,sdd)'
Mxgate_3._12 net_1 net_4 net_2 vdd p W='1.54*1u' L=lp_min
+ ad='areap(1.54,sdd)' as='areap(1.54,sdd)' pd='perip(1.54,sdd)'
+ ps='perip(1.54,sdd)'
Mxgate_3._13 net_1 sel0 net_2 gnd n W='0.77*1u' L=ln_min
+ ad='arean(0.77,sdd)' as='arean(0.77,sdd)' pd='perin(0.77,sdd)'
+ ps='perin(0.77,sdd)'
Minverter_3._14 net_2 in1 gnd gnd n W='0.77*1u' L=ln_min
+ ad='arean(0.77,sdd)' as='arean(0.77,sdd)' pd='perin(0.77,sdd)'
+ ps='perin(0.77,sdd)'
Minverter_3._15 net_2 in1 vdd vdd p W='1.54*1u' L=lp_min
+ ad='areap(1.54,sdd)' as='areap(1.54,sdd)' pd='perip(1.54,sdd)'
+ ps='perip(1.54,sdd)'
Minverter_4._16 net_4 sel0 gnd gnd n W='0.385*1u' L=ln_min
+ ad='arean(0.385,sdd)' as='arean(0.385,sdd)' pd='perin(0.385,sdd)'
+ ps='perin(0.385,sdd)'
Minverter_4._17 net_4 sel0 vdd vdd p W='0.77*1u' L=lp_min
+ ad='areap(0.77,sdd)' as='areap(0.77,sdd)' pd='perip(0.77,sdd)'
+ ps='perip(0.77,sdd)'
Minverter_5._18 out N2 gnd gnd n W='0.77*1u' L=ln_min ad='arean(0.77,sdd)'
+ as='arean(0.77,sdd)' pd='perin(0.77,sdd)' ps='perin(0.77,sdd)'
Minverter_5._19 out N2 vdd vdd p W='1.54*1u' L=lp_min ad='areap(1.54,sdd)'
+ as='areap(1.54,sdd)' pd='perip(1.54,sdd)' ps='perip(1.54,sdd)'
Minverter_6._20 N1 net_1 gnd gnd n W='0.77*1u' L=ln_min
+ ad='arean(0.77,sdd)' as='arean(0.77,sdd)' pd='perin(0.77,sdd)'
+ ps='perin(0.77,sdd)'
Minverter_6._21 N1 net_1 vdd vdd p W='1.54*1u' L=lp_min
+ ad='areap(1.54,sdd)' as='areap(1.54,sdd)' pd='perip(1.54,sdd)'
+ ps='perip(1.54,sdd)'
Minverter_7._22 net_5 in2 gnd gnd n W='0.385*1u' L=ln_min
+ ad='arean(0.385,sdd)' as='arean(0.385,sdd)' pd='perin(0.385,sdd)'
+ ps='perin(0.385,sdd)'
Minverter_7._23 net_5 in2 vdd vdd p W='0.77*1u' L=lp_min
+ ad='areap(0.77,sdd)' as='areap(0.77,sdd)' pd='perip(0.77,sdd)'
+ ps='perip(0.77,sdd)'
*.ENDS	$ MMI_MUXI3B
