* FILE: MMI_OA31B.sp

* SPICE netlist for "MMI_OA31B" (generated by MMI_SUE4.2.16)

*.SUBCKT MMI_OA31B in0 in1 in2 in3 out
Minverter1._0 out N1 gnd gnd n W='0.77*1u' L=ln_min ad='arean(0.77,sdd)'
+ as='arean(0.77,sdd)' pd='perin(0.77,sdd)' ps='perin(0.77,sdd)'
Minverter1._1 out N1 vdd vdd p W='1.54*1u' L=lp_min ad='areap(1.54,sdd)'
+ as='areap(1.54,sdd)' pd='perip(1.54,sdd)' ps='perip(1.54,sdd)'
M_2_1 N1 in0 net_1 gnd n W='0.77*1u' L=ln_min ad='arean(0.77,sdd)'
+ as='arean(0.77,sdd)' pd='perin(0.77,sdd)' ps='perin(0.77,sdd)'
M_3_1 net_1 in1 gnd gnd n W='0.77*1u' L=ln_min ad='arean(0.77,sdd)'
+ as='arean(0.77,sdd)' pd='perin(0.77,sdd)' ps='perin(0.77,sdd)'
M_4_1 net_1 in2 gnd gnd n W='0.77*1u' L=ln_min ad='arean(0.77,sdd)'
+ as='arean(0.77,sdd)' pd='perin(0.77,sdd)' ps='perin(0.77,sdd)'
M_5_1 net_1 in3 gnd gnd n W='0.77*1u' L=ln_min ad='arean(0.77,sdd)'
+ as='arean(0.77,sdd)' pd='perin(0.77,sdd)' ps='perin(0.77,sdd)'
M_6_1 N1 in0 vdd vdd p W='0.77*1u' L=lp_min ad='areap(0.77,sdd)'
+ as='areap(0.77,sdd)' pd='perip(0.77,sdd)' ps='perip(0.77,sdd)'
M_7_1 N1 in1 net_3 vdd p W='1.155*1u' L=lp_min ad='areap(1.155,sdd)'
+ as='areap(1.155,sdd)' pd='perip(1.155,sdd)' ps='perip(1.155,sdd)'
M_8_1 N1 in1 net_2 vdd p W='1.155*1u' L=lp_min ad='areap(1.155,sdd)'
+ as='areap(1.155,sdd)' pd='perip(1.155,sdd)' ps='perip(1.155,sdd)'
M_9_1 net_2 in2 net_5 vdd p W='1.155*1u' L=lp_min ad='areap(1.155,sdd)'
+ as='areap(1.155,sdd)' pd='perip(1.155,sdd)' ps='perip(1.155,sdd)'
M_10_1 net_3 in2 net_4 vdd p W='1.155*1u' L=lp_min ad='areap(1.155,sdd)'
+ as='areap(1.155,sdd)' pd='perip(1.155,sdd)' ps='perip(1.155,sdd)'
M_11_1 net_5 in3 vdd vdd p W='1.155*1u' L=lp_min ad='areap(1.155,sdd)'
+ as='areap(1.155,sdd)' pd='perip(1.155,sdd)' ps='perip(1.155,sdd)'
M_12_1 net_4 in3 vdd vdd p W='1.155*1u' L=lp_min ad='areap(1.155,sdd)'
+ as='areap(1.155,sdd)' pd='perip(1.155,sdd)' ps='perip(1.155,sdd)'
*.ENDS	$ MMI_OA31B
