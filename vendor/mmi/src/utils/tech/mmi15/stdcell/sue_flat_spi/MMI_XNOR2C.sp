* FILE: MMI_XNOR2C.sp

* SPICE netlist for "MMI_XNOR2C" (generated by MMI_SUE4.2.16)

*.SUBCKT MMI_XNOR2C in0 in1 out
MMMI_NAND2B._0 MMI_NAND2B%net_1 in1 gnd gnd n W='1.54*1u' L=ln_min
+ ad='arean(1.54,sdd)' as='arean(1.54,sdd)' pd='perin(1.54,sdd)'
+ ps='perin(1.54,sdd)'
MMMI_NAND2B._1 net_1 in0 MMI_NAND2B%net_1 gnd n W='1.54*1u' L=ln_min
+ ad='arean(1.54,sdd)' as='arean(1.54,sdd)' pd='perin(1.54,sdd)'
+ ps='perin(1.54,sdd)'
MMMI_NAND2B._2 net_1 in1 vdd vdd p W='1.54*1u' L=lp_min
+ ad='areap(1.54,sdd)' as='areap(1.54,sdd)' pd='perip(1.54,sdd)'
+ ps='perip(1.54,sdd)'
MMMI_NAND2B._3 net_1 in0 vdd vdd p W='1.54*1u' L=lp_min
+ ad='areap(1.54,sdd)' as='areap(1.54,sdd)' pd='perip(1.54,sdd)'
+ ps='perip(1.54,sdd)'
MMMI_OAI21C._4 out net_1 MMI_OAI21C%net_1 gnd n W='3.08*1u' L=ln_min
+ ad='arean(3.08,sdd)' as='arean(3.08,sdd)' pd='perin(3.08,sdd)'
+ ps='perin(3.08,sdd)'
MMMI_OAI21C._5 MMI_OAI21C%net_1 in1 gnd gnd n W='3.08*1u' L=ln_min
+ ad='arean(3.08,sdd)' as='arean(3.08,sdd)' pd='perin(3.08,sdd)'
+ ps='perin(3.08,sdd)'
MMMI_OAI21C._6 MMI_OAI21C%net_1 in0 gnd gnd n W='3.08*1u' L=ln_min
+ ad='arean(3.08,sdd)' as='arean(3.08,sdd)' pd='perin(3.08,sdd)'
+ ps='perin(3.08,sdd)'
MMMI_OAI21C._7 out net_1 vdd vdd p W='3.08*1u' L=lp_min
+ ad='areap(3.08,sdd)' as='areap(3.08,sdd)' pd='perip(3.08,sdd)'
+ ps='perip(3.08,sdd)'
MMMI_OAI21C._8 out in1 MMI_OAI21C%net_3 vdd p W='1.54*1u' L=lp_min
+ ad='areap(1.54,sdd)' as='areap(1.54,sdd)' pd='perip(1.54,sdd)'
+ ps='perip(1.54,sdd)'
MMMI_OAI21C._9 out in1 MMI_OAI21C%net_4 vdd p W='1.54*1u' L=lp_min
+ ad='areap(1.54,sdd)' as='areap(1.54,sdd)' pd='perip(1.54,sdd)'
+ ps='perip(1.54,sdd)'
MMMI_OAI21C._10 out in1 MMI_OAI21C%net_2 vdd p W='1.54*1u' L=lp_min
+ ad='areap(1.54,sdd)' as='areap(1.54,sdd)' pd='perip(1.54,sdd)'
+ ps='perip(1.54,sdd)'
MMMI_OAI21C._11 out in1 MMI_OAI21C%net_5 vdd p W='1.54*1u' L=lp_min
+ ad='areap(1.54,sdd)' as='areap(1.54,sdd)' pd='perip(1.54,sdd)'
+ ps='perip(1.54,sdd)'
MMMI_OAI21C._12 MMI_OAI21C%net_3 in0 vdd vdd p W='1.54*1u' L=lp_min
+ ad='areap(1.54,sdd)' as='areap(1.54,sdd)' pd='perip(1.54,sdd)'
+ ps='perip(1.54,sdd)'
MMMI_OAI21C._13 MMI_OAI21C%net_4 in0 vdd vdd p W='1.54*1u' L=lp_min
+ ad='areap(1.54,sdd)' as='areap(1.54,sdd)' pd='perip(1.54,sdd)'
+ ps='perip(1.54,sdd)'
MMMI_OAI21C._14 MMI_OAI21C%net_2 in0 vdd vdd p W='1.54*1u' L=lp_min
+ ad='areap(1.54,sdd)' as='areap(1.54,sdd)' pd='perip(1.54,sdd)'
+ ps='perip(1.54,sdd)'
MMMI_OAI21C._15 MMI_OAI21C%net_5 in0 vdd vdd p W='1.54*1u' L=lp_min
+ ad='areap(1.54,sdd)' as='areap(1.54,sdd)' pd='perip(1.54,sdd)'
+ ps='perip(1.54,sdd)'
*.ENDS	$ MMI_XNOR2C
