* FILE: MMI_KEEPW.sp

* SPICE netlist for "MMI_KEEPW" (generated by MMI_SUE4.2.16)

*.SUBCKT MMI_KEEPW in
M_0 in net_1 vdd vdd p W='0.35*1u' L=lp_min ad='areap(0.35,sdd)'
+ as='areap(0.35,sdd)' pd='perip(0.35,sdd)' ps='perip(0.35,sdd)'
M_1_1 net_1 in vdd vdd p W='0.35*1u' L=lp_min ad='areap(0.35,sdd)'
+ as='areap(0.35,sdd)' pd='perip(0.35,sdd)' ps='perip(0.35,sdd)'
M_2_1 in net_1 gnd gnd n W='0.35*1u' L='2*ln_min' ad='arean(0.35,sdd)'
+ as='arean(0.35,sdd)' pd='perin(0.35,sdd)' ps='perin(0.35,sdd)'
M_3_1 net_1 in gnd gnd n W='0.35*1u' L='2*ln_min' ad='arean(0.35,sdd)'
+ as='arean(0.35,sdd)' pd='perin(0.35,sdd)' ps='perin(0.35,sdd)'
*.ENDS	$ MMI_KEEPW
