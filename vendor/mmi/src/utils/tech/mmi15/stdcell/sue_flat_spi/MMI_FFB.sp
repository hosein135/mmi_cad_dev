* FILE: MMI_FFB.sp

* SPICE netlist for "MMI_FFB" (generated by MMI_SUE4.2.16)

*.SUBCKT MMI_FFB clk d q
Minverter._0 q N5 gnd gnd n W='0.77*1u' L=ln_min ad='arean(0.77,sdd)'
+ as='arean(0.77,sdd)' pd='perin(0.77,sdd)' ps='perin(0.77,sdd)'
Minverter._1 q N5 vdd vdd p W='1.54*1u' L=lp_min ad='areap(1.54,sdd)'
+ as='areap(1.54,sdd)' pd='perip(1.54,sdd)' ps='perip(1.54,sdd)'
Minverter_1._2 clk_L clk gnd gnd n W='0.385*1u' L=ln_min
+ ad='arean(0.385,sdd)' as='arean(0.385,sdd)' pd='perin(0.385,sdd)'
+ ps='perin(0.385,sdd)'
Minverter_1._3 clk_L clk vdd vdd p W='0.77*1u' L=lp_min
+ ad='areap(0.77,sdd)' as='areap(0.77,sdd)' pd='perip(0.77,sdd)'
+ ps='perip(0.77,sdd)'
M_4_1 net_5 N5 gnd gnd n W='0.35*1u' L=ln_min ad='arean(0.35,sdd)'
+ as='arean(0.35,sdd)' pd='perin(0.35,sdd)' ps='perin(0.35,sdd)'
M_5_1 N4 clk net_3 vdd p W='0.35*1u' L=lp_min ad='areap(0.35,sdd)'
+ as='areap(0.35,sdd)' pd='perip(0.35,sdd)' ps='perip(0.35,sdd)'
M_6_1 N4 clk_L net_5 gnd n W='0.35*1u' L=ln_min ad='arean(0.35,sdd)'
+ as='arean(0.35,sdd)' pd='perin(0.35,sdd)' ps='perin(0.35,sdd)'
M_7_1 net_3 N5 vdd vdd p W='0.35*1u' L=lp_min ad='areap(0.35,sdd)'
+ as='areap(0.35,sdd)' pd='perip(0.35,sdd)' ps='perip(0.35,sdd)'
M_8_1 net_2 N3 vdd vdd p W='0.35*1u' L=lp_min ad='areap(0.35,sdd)'
+ as='areap(0.35,sdd)' pd='perip(0.35,sdd)' ps='perip(0.35,sdd)'
M_9_1 N2 clk_L net_2 vdd p W='0.35*1u' L=lp_min ad='areap(0.35,sdd)'
+ as='areap(0.35,sdd)' pd='perip(0.35,sdd)' ps='perip(0.35,sdd)'
M_10_1 N2 clk net_4 gnd n W='0.35*1u' L=ln_min ad='arean(0.35,sdd)'
+ as='arean(0.35,sdd)' pd='perin(0.35,sdd)' ps='perin(0.35,sdd)'
M_11_1 net_4 N3 gnd gnd n W='0.35*1u' L=ln_min ad='arean(0.35,sdd)'
+ as='arean(0.35,sdd)' pd='perin(0.35,sdd)' ps='perin(0.35,sdd)'
Mxgate._12 N4 clk_L N3 vdd p W='0.77*1u' L=lp_min ad='areap(0.77,sdd)'
+ as='areap(0.77,sdd)' pd='perip(0.77,sdd)' ps='perip(0.77,sdd)'
Mxgate._13 N4 clk N3 gnd n W='0.35*1u' L=ln_min ad='arean(0.35,sdd)'
+ as='arean(0.35,sdd)' pd='perin(0.35,sdd)' ps='perin(0.35,sdd)'
Mxgate_1._14 net_1 clk N2 vdd p W='0.77*1u' L=lp_min ad='areap(0.77,sdd)'
+ as='areap(0.77,sdd)' pd='perip(0.77,sdd)' ps='perip(0.77,sdd)'
Mxgate_1._15 net_1 clk_L N2 gnd n W='0.35*1u' L=ln_min ad='arean(0.35,sdd)'
+ as='arean(0.35,sdd)' pd='perin(0.35,sdd)' ps='perin(0.35,sdd)'
Minverter_2._16 N5 N4 gnd gnd n W='0.52*1u' L=ln_min ad='arean(0.52,sdd)'
+ as='arean(0.52,sdd)' pd='perin(0.52,sdd)' ps='perin(0.52,sdd)'
Minverter_2._17 N5 N4 vdd vdd p W='0.77*1u' L=lp_min ad='areap(0.77,sdd)'
+ as='areap(0.77,sdd)' pd='perip(0.77,sdd)' ps='perip(0.77,sdd)'
Minverter_3._18 N3 N2 gnd gnd n W='0.385*1u' L=ln_min ad='arean(0.385,sdd)'
+ as='arean(0.385,sdd)' pd='perin(0.385,sdd)' ps='perin(0.385,sdd)'
Minverter_3._19 N3 N2 vdd vdd p W='0.77*1u' L=lp_min ad='areap(0.77,sdd)'
+ as='areap(0.77,sdd)' pd='perip(0.77,sdd)' ps='perip(0.77,sdd)'
Minverter_4._20 net_1 d gnd gnd n W='0.385*1u' L=ln_min
+ ad='arean(0.385,sdd)' as='arean(0.385,sdd)' pd='perin(0.385,sdd)'
+ ps='perin(0.385,sdd)'
Minverter_4._21 net_1 d vdd vdd p W='0.77*1u' L=lp_min ad='areap(0.77,sdd)'
+ as='areap(0.77,sdd)' pd='perip(0.77,sdd)' ps='perip(0.77,sdd)'
.ic N4=0V
*.ENDS	$ MMI_FFB
