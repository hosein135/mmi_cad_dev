* FILE: MMI_INAND2A.sp

* SPICE netlist for "MMI_INAND2A" (generated by MMI_SUE4.2.16)

*.SUBCKT MMI_INAND2A in0 in1 out
Mnand2._0 out in1_L vdd vdd p W='0.77*1u' L=lp_min ad='areap(0.77,sdd)'
+ as='areap(0.77,sdd)' pd='perip(0.77,sdd)' ps='perip(0.77,sdd)'
Mnand2._1 out in1_L nand2%net_1 gnd n W='0.77*1u' L=ln_min
+ ad='arean(0.77,sdd)' as='arean(0.77,sdd)' pd='perin(0.77,sdd)'
+ ps='perin(0.77,sdd)'
Mnand2._2 out in0 vdd vdd p W='0.77*1u' L=lp_min ad='areap(0.77,sdd)'
+ as='areap(0.77,sdd)' pd='perip(0.77,sdd)' ps='perip(0.77,sdd)'
Mnand2._3 nand2%net_1 in0 gnd gnd n W='0.77*1u' L=ln_min
+ ad='arean(0.77,sdd)' as='arean(0.77,sdd)' pd='perin(0.77,sdd)'
+ ps='perin(0.77,sdd)'
Minverter._4 in1_L in1 gnd gnd n W='0.385*1u' L=ln_min
+ ad='arean(0.385,sdd)' as='arean(0.385,sdd)' pd='perin(0.385,sdd)'
+ ps='perin(0.385,sdd)'
Minverter._5 in1_L in1 vdd vdd p W='0.77*1u' L=lp_min ad='areap(0.77,sdd)'
+ as='areap(0.77,sdd)' pd='perip(0.77,sdd)' ps='perip(0.77,sdd)'
*.ENDS	$ MMI_INAND2A
