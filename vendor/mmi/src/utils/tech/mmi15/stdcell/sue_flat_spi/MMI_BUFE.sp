* FILE: MMI_BUFE.sp

* SPICE netlist for "MMI_BUFE" (generated by MMI_SUE4.2.16)

*.SUBCKT MMI_BUFE in out
M_0 out N1 vdd vdd p W='12.32*1u' L=lp_min ad='areap(12.32,sdd)'
+ as='areap(12.32,sdd)' pd='perip(12.32,sdd)' ps='perip(12.32,sdd)'
M_1_1 out N1 gnd gnd n W='6.16*1u' L=ln_min ad='arean(6.16,sdd)'
+ as='arean(6.16,sdd)' pd='perin(6.16,sdd)' ps='perin(6.16,sdd)'
M_2_1 N1 in gnd gnd n W='2.08*1u' L=ln_min ad='arean(2.08,sdd)'
+ as='arean(2.08,sdd)' pd='perin(2.08,sdd)' ps='perin(2.08,sdd)'
M_3_1 N1 in vdd vdd p W='4.16*1u' L=lp_min ad='areap(4.16,sdd)'
+ as='areap(4.16,sdd)' pd='perip(4.16,sdd)' ps='perip(4.16,sdd)'
*.ENDS	$ MMI_BUFE
