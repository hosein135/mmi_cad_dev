* FILE: MMI_NOR3A.sp

* SPICE netlist for "MMI_NOR3A" (generated by MMI_SUE4.2.16)

*.SUBCKT MMI_NOR3A in0 in1 in2 out
M_0 out in0 gnd gnd n W='0.385*1u' L=ln_min ad='arean(0.385,sdd)'
+ as='arean(0.385,sdd)' pd='perin(0.385,sdd)' ps='perin(0.385,sdd)'
M_1_1 out in1 gnd gnd n W='0.385*1u' L=ln_min ad='arean(0.385,sdd)'
+ as='arean(0.385,sdd)' pd='perin(0.385,sdd)' ps='perin(0.385,sdd)'
M_2_1 out in2 gnd gnd n W='0.385*1u' L=ln_min ad='arean(0.385,sdd)'
+ as='arean(0.385,sdd)' pd='perin(0.385,sdd)' ps='perin(0.385,sdd)'
M_3_1 out in0 net_1 vdd p W='2.31*1u' L=lp_min ad='areap(2.31,sdd)'
+ as='areap(2.31,sdd)' pd='perip(2.31,sdd)' ps='perip(2.31,sdd)'
M_4_1 net_1 in1 net_2 vdd p W='2.31*1u' L=lp_min ad='areap(2.31,sdd)'
+ as='areap(2.31,sdd)' pd='perip(2.31,sdd)' ps='perip(2.31,sdd)'
M_5_1 net_2 in2 vdd vdd p W='2.31*1u' L=lp_min ad='areap(2.31,sdd)'
+ as='areap(2.31,sdd)' pd='perip(2.31,sdd)' ps='perip(2.31,sdd)'
*.ENDS	$ MMI_NOR3A
