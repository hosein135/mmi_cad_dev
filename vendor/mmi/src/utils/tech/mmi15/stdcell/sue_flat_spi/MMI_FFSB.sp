* FILE: MMI_FFSB.sp

* SPICE netlist for "MMI_FFSB" (generated by MMI_SUE4.2.16)

*.SUBCKT MMI_FFSB clk d q setb
Minverter._0 q N5 gnd gnd n W='0.77*1u' L=ln_min ad='arean(0.77,sdd)'
+ as='arean(0.77,sdd)' pd='perin(0.77,sdd)' ps='perin(0.77,sdd)'
Minverter._1 q N5 vdd vdd p W='1.54*1u' L=lp_min ad='areap(1.54,sdd)'
+ as='areap(1.54,sdd)' pd='perip(1.54,sdd)' ps='perip(1.54,sdd)'
Minverter_1._2 clk_L clk gnd gnd n W='0.385*1u' L=ln_min
+ ad='arean(0.385,sdd)' as='arean(0.385,sdd)' pd='perin(0.385,sdd)'
+ ps='perin(0.385,sdd)'
Minverter_1._3 clk_L clk vdd vdd p W='0.77*1u' L=lp_min
+ ad='areap(0.77,sdd)' as='areap(0.77,sdd)' pd='perip(0.77,sdd)'
+ ps='perip(0.77,sdd)'
M_4_1 net_4 N5 gnd gnd n W='0.35*1u' L=ln_min ad='arean(0.35,sdd)'
+ as='arean(0.35,sdd)' pd='perin(0.35,sdd)' ps='perin(0.35,sdd)'
M_5_1 N4 clk net_3 vdd p W='0.35*1u' L=lp_min ad='areap(0.35,sdd)'
+ as='areap(0.35,sdd)' pd='perip(0.35,sdd)' ps='perip(0.35,sdd)'
M_6_1 N4 clk_L net_4 gnd n W='0.35*1u' L=ln_min ad='arean(0.35,sdd)'
+ as='arean(0.35,sdd)' pd='perin(0.35,sdd)' ps='perin(0.35,sdd)'
M_7_1 net_3 N5 vdd vdd p W='0.35*1u' L=lp_min ad='areap(0.35,sdd)'
+ as='areap(0.35,sdd)' pd='perip(0.35,sdd)' ps='perip(0.35,sdd)'
M_8_1 net_1 N3 vdd vdd p W='0.35*1u' L=lp_min ad='areap(0.35,sdd)'
+ as='areap(0.35,sdd)' pd='perip(0.35,sdd)' ps='perip(0.35,sdd)'
M_9_1 N2 clk_L net_1 vdd p W='0.35*1u' L=lp_min ad='areap(0.35,sdd)'
+ as='areap(0.35,sdd)' pd='perip(0.35,sdd)' ps='perip(0.35,sdd)'
M_10_1 N2 clk net_2 gnd n W='0.35*1u' L=ln_min ad='arean(0.35,sdd)'
+ as='arean(0.35,sdd)' pd='perin(0.35,sdd)' ps='perin(0.35,sdd)'
M_11_1 net_2 N3 gnd gnd n W='0.35*1u' L=ln_min ad='arean(0.35,sdd)'
+ as='arean(0.35,sdd)' pd='perin(0.35,sdd)' ps='perin(0.35,sdd)'
Mxgate._12 N4 clk_L N3 vdd p W='0.77*1u' L=lp_min ad='areap(0.77,sdd)'
+ as='areap(0.77,sdd)' pd='perip(0.77,sdd)' ps='perip(0.77,sdd)'
Mxgate._13 N4 clk N3 gnd n W='0.35*1u' L=ln_min ad='arean(0.35,sdd)'
+ as='arean(0.35,sdd)' pd='perin(0.35,sdd)' ps='perin(0.35,sdd)'
Mxgate_1._14 N1 clk N2 vdd p W='0.77*1u' L=lp_min ad='areap(0.77,sdd)'
+ as='areap(0.77,sdd)' pd='perip(0.77,sdd)' ps='perip(0.77,sdd)'
Mxgate_1._15 N1 clk_L N2 gnd n W='0.35*1u' L=ln_min ad='arean(0.35,sdd)'
+ as='arean(0.35,sdd)' pd='perin(0.35,sdd)' ps='perin(0.35,sdd)'
Mnor2._16 N5 N4 gnd gnd n W='0.52*1u' L=ln_min ad='arean(0.52,sdd)'
+ as='arean(0.52,sdd)' pd='perin(0.52,sdd)' ps='perin(0.52,sdd)'
Mnor2._17 N5 N4 nor2%net_1 vdd p W='1.54*1u' L=lp_min ad='areap(1.54,sdd)'
+ as='areap(1.54,sdd)' pd='perip(1.54,sdd)' ps='perip(1.54,sdd)'
Mnor2._18 N5 set gnd gnd n W='0.52*1u' L=ln_min ad='arean(0.52,sdd)'
+ as='arean(0.52,sdd)' pd='perin(0.52,sdd)' ps='perin(0.52,sdd)'
Mnor2._19 nor2%net_1 set vdd vdd p W='1.54*1u' L=lp_min
+ ad='areap(1.54,sdd)' as='areap(1.54,sdd)' pd='perip(1.54,sdd)'
+ ps='perip(1.54,sdd)'
Mnand2._20 N3 N2 vdd vdd p W='0.77*1u' L=lp_min ad='areap(0.77,sdd)'
+ as='areap(0.77,sdd)' pd='perip(0.77,sdd)' ps='perip(0.77,sdd)'
Mnand2._21 N3 N2 nand2%net_1 gnd n W='0.77*1u' L=ln_min
+ ad='arean(0.77,sdd)' as='arean(0.77,sdd)' pd='perin(0.77,sdd)'
+ ps='perin(0.77,sdd)'
Mnand2._22 N3 setb vdd vdd p W='0.77*1u' L=lp_min ad='areap(0.77,sdd)'
+ as='areap(0.77,sdd)' pd='perip(0.77,sdd)' ps='perip(0.77,sdd)'
Mnand2._23 nand2%net_1 setb gnd gnd n W='0.77*1u' L=ln_min
+ ad='arean(0.77,sdd)' as='arean(0.77,sdd)' pd='perin(0.77,sdd)'
+ ps='perin(0.77,sdd)'
Minverter_2._24 set setb gnd gnd n W='0.52*1u' L=ln_min
+ ad='arean(0.52,sdd)' as='arean(0.52,sdd)' pd='perin(0.52,sdd)'
+ ps='perin(0.52,sdd)'
Minverter_2._25 set setb vdd vdd p W='1.04*1u' L=lp_min
+ ad='areap(1.04,sdd)' as='areap(1.04,sdd)' pd='perip(1.04,sdd)'
+ ps='perip(1.04,sdd)'
Minverter_3._26 N1 d gnd gnd n W='0.77*1u' L=ln_min ad='arean(0.77,sdd)'
+ as='arean(0.77,sdd)' pd='perin(0.77,sdd)' ps='perin(0.77,sdd)'
Minverter_3._27 N1 d vdd vdd p W='1.54*1u' L=lp_min ad='areap(1.54,sdd)'
+ as='areap(1.54,sdd)' pd='perip(1.54,sdd)' ps='perip(1.54,sdd)'
.ic N4=0V
*.ENDS	$ MMI_FFSB
