* FILE: MMI_OAI31A.sp

* SPICE netlist for "MMI_OAI31A" (generated by MMI_SUE4.2.16)

*.SUBCKT MMI_OAI31A in0 in1 in2 in3 out
M_0 out in0 net_1 gnd n W='0.77*1u' L=ln_min ad='arean(0.77,sdd)'
+ as='arean(0.77,sdd)' pd='perin(0.77,sdd)' ps='perin(0.77,sdd)'
M_1_1 net_1 in1 gnd gnd n W='0.77*1u' L=ln_min ad='arean(0.77,sdd)'
+ as='arean(0.77,sdd)' pd='perin(0.77,sdd)' ps='perin(0.77,sdd)'
M_2_1 net_1 in2 gnd gnd n W='0.77*1u' L=ln_min ad='arean(0.77,sdd)'
+ as='arean(0.77,sdd)' pd='perin(0.77,sdd)' ps='perin(0.77,sdd)'
M_3_1 net_1 in3 gnd gnd n W='0.77*1u' L=ln_min ad='arean(0.77,sdd)'
+ as='arean(0.77,sdd)' pd='perin(0.77,sdd)' ps='perin(0.77,sdd)'
M_4_1 out in0 vdd vdd p W='0.77*1u' L=lp_min ad='areap(0.77,sdd)'
+ as='areap(0.77,sdd)' pd='perip(0.77,sdd)' ps='perip(0.77,sdd)'
M_5_1 net_3 in3 vdd vdd p W='2.31*1u' L=lp_min ad='areap(2.31,sdd)'
+ as='areap(2.31,sdd)' pd='perip(2.31,sdd)' ps='perip(2.31,sdd)'
M_6_1 net_2 in2 net_3 vdd p W='2.31*1u' L=lp_min ad='areap(2.31,sdd)'
+ as='areap(2.31,sdd)' pd='perip(2.31,sdd)' ps='perip(2.31,sdd)'
M_7_1 out in1 net_2 vdd p W='2.31*1u' L=lp_min ad='areap(2.31,sdd)'
+ as='areap(2.31,sdd)' pd='perip(2.31,sdd)' ps='perip(2.31,sdd)'
*.ENDS	$ MMI_OAI31A
