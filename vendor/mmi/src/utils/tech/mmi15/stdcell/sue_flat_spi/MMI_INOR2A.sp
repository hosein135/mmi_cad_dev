* FILE: MMI_INOR2A.sp

* SPICE netlist for "MMI_INOR2A" (generated by MMI_SUE4.2.16)

*.SUBCKT MMI_INOR2A in0 in1 out
Mnor2._0 out in1_L gnd gnd n W='0.385*1u' L=ln_min ad='arean(0.385,sdd)'
+ as='arean(0.385,sdd)' pd='perin(0.385,sdd)' ps='perin(0.385,sdd)'
Mnor2._1 out in1_L nor2%net_1 vdd p W='1.54*1u' L=lp_min
+ ad='areap(1.54,sdd)' as='areap(1.54,sdd)' pd='perip(1.54,sdd)'
+ ps='perip(1.54,sdd)'
Mnor2._2 out in0 gnd gnd n W='0.385*1u' L=ln_min ad='arean(0.385,sdd)'
+ as='arean(0.385,sdd)' pd='perin(0.385,sdd)' ps='perin(0.385,sdd)'
Mnor2._3 nor2%net_1 in0 vdd vdd p W='1.54*1u' L=lp_min ad='areap(1.54,sdd)'
+ as='areap(1.54,sdd)' pd='perip(1.54,sdd)' ps='perip(1.54,sdd)'
Minverter._4 in1_L in1 gnd gnd n W='0.385*1u' L=ln_min
+ ad='arean(0.385,sdd)' as='arean(0.385,sdd)' pd='perin(0.385,sdd)'
+ ps='perin(0.385,sdd)'
Minverter._5 in1_L in1 vdd vdd p W='0.77*1u' L=lp_min ad='areap(0.77,sdd)'
+ as='areap(0.77,sdd)' pd='perip(0.77,sdd)' ps='perip(0.77,sdd)'
*.ENDS	$ MMI_INOR2A
