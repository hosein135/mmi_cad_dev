* FILE: MMI_NAND2D.sp

* SPICE netlist for "MMI_NAND2D" (generated by MMI_SUE4.2.16)

*.SUBCKT MMI_NAND2D in0 in1 out
M_0 out in0 vdd vdd p W='3.08*1u' L=lp_min ad='areap(3.08,sdd)'
+ as='areap(3.08,sdd)' pd='perip(3.08,sdd)' ps='perip(3.08,sdd)'
M_1_1 out in0 vdd vdd p W='3.08*1u' L=lp_min ad='areap(3.08,sdd)'
+ as='areap(3.08,sdd)' pd='perip(3.08,sdd)' ps='perip(3.08,sdd)'
M_2_1 out in1 vdd vdd p W='3.08*1u' L=lp_min ad='areap(3.08,sdd)'
+ as='areap(3.08,sdd)' pd='perip(3.08,sdd)' ps='perip(3.08,sdd)'
M_3_1 out in1 vdd vdd p W='3.08*1u' L=lp_min ad='areap(3.08,sdd)'
+ as='areap(3.08,sdd)' pd='perip(3.08,sdd)' ps='perip(3.08,sdd)'
M_4_1 out in0 net_1 gnd n W='1.54*1u' L=ln_min ad='arean(1.54,sdd)'
+ as='arean(1.54,sdd)' pd='perin(1.54,sdd)' ps='perin(1.54,sdd)'
M_5_1 out in0 net_4 gnd n W='1.54*1u' L=ln_min ad='arean(1.54,sdd)'
+ as='arean(1.54,sdd)' pd='perin(1.54,sdd)' ps='perin(1.54,sdd)'
M_6_1 net_1 in1 gnd gnd n W='1.54*1u' L=ln_min ad='arean(1.54,sdd)'
+ as='arean(1.54,sdd)' pd='perin(1.54,sdd)' ps='perin(1.54,sdd)'
M_7_1 net_4 in1 gnd gnd n W='1.54*1u' L=ln_min ad='arean(1.54,sdd)'
+ as='arean(1.54,sdd)' pd='perin(1.54,sdd)' ps='perin(1.54,sdd)'
M_8_1 out in0 net_3 gnd n W='1.54*1u' L=ln_min ad='arean(1.54,sdd)'
+ as='arean(1.54,sdd)' pd='perin(1.54,sdd)' ps='perin(1.54,sdd)'
M_9_1 out in0 net_2 gnd n W='1.54*1u' L=ln_min ad='arean(1.54,sdd)'
+ as='arean(1.54,sdd)' pd='perin(1.54,sdd)' ps='perin(1.54,sdd)'
M_10_1 net_3 in1 gnd gnd n W='1.54*1u' L=ln_min ad='arean(1.54,sdd)'
+ as='arean(1.54,sdd)' pd='perin(1.54,sdd)' ps='perin(1.54,sdd)'
M_11_1 net_2 in1 gnd gnd n W='1.54*1u' L=ln_min ad='arean(1.54,sdd)'
+ as='arean(1.54,sdd)' pd='perin(1.54,sdd)' ps='perin(1.54,sdd)'
*.ENDS	$ MMI_NAND2D
