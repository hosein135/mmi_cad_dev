* FILE: MMI_AOI21C.sp

* SPICE netlist for "MMI_AOI21C" (generated by MMI_SUE4.2.16)

*.SUBCKT MMI_AOI21C in0 in1 in2 out
M_0 out in0 gnd gnd n W='1.54*1u' L=ln_min ad='arean(1.54,sdd)'
+ as='arean(1.54,sdd)' pd='perin(1.54,sdd)' ps='perin(1.54,sdd)'
M_1_1 out in1 net_1 gnd n W='3.08*1u' L=ln_min ad='arean(3.08,sdd)'
+ as='arean(3.08,sdd)' pd='perin(3.08,sdd)' ps='perin(3.08,sdd)'
M_2_1 net_1 in2 gnd gnd n W='3.08*1u' L=ln_min ad='arean(3.08,sdd)'
+ as='arean(3.08,sdd)' pd='perin(3.08,sdd)' ps='perin(3.08,sdd)'
M_3_1 out in0 net_2 vdd p W='6.16*1u' L=lp_min ad='areap(6.16,sdd)'
+ as='areap(6.16,sdd)' pd='perip(6.16,sdd)' ps='perip(6.16,sdd)'
M_4_1 net_2 in2 vdd vdd p W='6.16*1u' L=lp_min ad='areap(6.16,sdd)'
+ as='areap(6.16,sdd)' pd='perip(6.16,sdd)' ps='perip(6.16,sdd)'
M_5_1 net_2 in1 vdd vdd p W='6.16*1u' L=lp_min ad='areap(6.16,sdd)'
+ as='areap(6.16,sdd)' pd='perip(6.16,sdd)' ps='perip(6.16,sdd)'
*.ENDS	$ MMI_AOI21C
