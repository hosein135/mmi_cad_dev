* FILE: MMI_XNOR2B.sp

* SPICE netlist for "MMI_XNOR2B" (generated by MMI_SUE4.2.16)

*.SUBCKT MMI_XNOR2B in0 in1 out
MMMI_NAND2A._0 MMI_NAND2A%net_1 in1 gnd gnd n W='0.77*1u' L=ln_min
+ ad='arean(0.77,sdd)' as='arean(0.77,sdd)' pd='perin(0.77,sdd)'
+ ps='perin(0.77,sdd)'
MMMI_NAND2A._1 net_1 in0 MMI_NAND2A%net_1 gnd n W='0.77*1u' L=ln_min
+ ad='arean(0.77,sdd)' as='arean(0.77,sdd)' pd='perin(0.77,sdd)'
+ ps='perin(0.77,sdd)'
MMMI_NAND2A._2 net_1 in1 vdd vdd p W='0.77*1u' L=lp_min
+ ad='areap(0.77,sdd)' as='areap(0.77,sdd)' pd='perip(0.77,sdd)'
+ ps='perip(0.77,sdd)'
MMMI_NAND2A._3 net_1 in0 vdd vdd p W='0.77*1u' L=lp_min
+ ad='areap(0.77,sdd)' as='areap(0.77,sdd)' pd='perip(0.77,sdd)'
+ ps='perip(0.77,sdd)'
MMMI_OAI21B._4 out net_1 MMI_OAI21B%net_1 gnd n W='1.54*1u' L=ln_min
+ ad='arean(1.54,sdd)' as='arean(1.54,sdd)' pd='perin(1.54,sdd)'
+ ps='perin(1.54,sdd)'
MMMI_OAI21B._5 MMI_OAI21B%net_1 in1 gnd gnd n W='1.54*1u' L=ln_min
+ ad='arean(1.54,sdd)' as='arean(1.54,sdd)' pd='perin(1.54,sdd)'
+ ps='perin(1.54,sdd)'
MMMI_OAI21B._6 MMI_OAI21B%net_1 in0 gnd gnd n W='1.54*1u' L=ln_min
+ ad='arean(1.54,sdd)' as='arean(1.54,sdd)' pd='perin(1.54,sdd)'
+ ps='perin(1.54,sdd)'
MMMI_OAI21B._7 out net_1 vdd vdd p W='1.54*1u' L=lp_min
+ ad='areap(1.54,sdd)' as='areap(1.54,sdd)' pd='perip(1.54,sdd)'
+ ps='perip(1.54,sdd)'
MMMI_OAI21B._8 out in1 MMI_OAI21B%net_2 vdd p W='1.54*1u' L=lp_min
+ ad='areap(1.54,sdd)' as='areap(1.54,sdd)' pd='perip(1.54,sdd)'
+ ps='perip(1.54,sdd)'
MMMI_OAI21B._9 out in1 MMI_OAI21B%net_3 vdd p W='1.54*1u' L=lp_min
+ ad='areap(1.54,sdd)' as='areap(1.54,sdd)' pd='perip(1.54,sdd)'
+ ps='perip(1.54,sdd)'
MMMI_OAI21B._10 MMI_OAI21B%net_2 in0 vdd vdd p W='1.54*1u' L=lp_min
+ ad='areap(1.54,sdd)' as='areap(1.54,sdd)' pd='perip(1.54,sdd)'
+ ps='perip(1.54,sdd)'
MMMI_OAI21B._11 MMI_OAI21B%net_3 in0 vdd vdd p W='1.54*1u' L=lp_min
+ ad='areap(1.54,sdd)' as='areap(1.54,sdd)' pd='perip(1.54,sdd)'
+ ps='perip(1.54,sdd)'
*.ENDS	$ MMI_XNOR2B
