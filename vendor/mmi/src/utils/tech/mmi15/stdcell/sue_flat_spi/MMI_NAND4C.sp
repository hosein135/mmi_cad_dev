* FILE: MMI_NAND4C.sp

* SPICE netlist for "MMI_NAND4C" (generated by MMI_SUE4.2.16)

*.SUBCKT MMI_NAND4C in0 in1 in2 in3 out
M_0 out in0 vdd vdd p W='1.54*1u' L=lp_min ad='areap(1.54,sdd)'
+ as='areap(1.54,sdd)' pd='perip(1.54,sdd)' ps='perip(1.54,sdd)'
M_1_1 out in0 vdd vdd p W='1.54*1u' L=lp_min ad='areap(1.54,sdd)'
+ as='areap(1.54,sdd)' pd='perip(1.54,sdd)' ps='perip(1.54,sdd)'
M_2_1 out in1 vdd vdd p W='1.54*1u' L=lp_min ad='areap(1.54,sdd)'
+ as='areap(1.54,sdd)' pd='perip(1.54,sdd)' ps='perip(1.54,sdd)'
M_3_1 out in1 vdd vdd p W='1.54*1u' L=lp_min ad='areap(1.54,sdd)'
+ as='areap(1.54,sdd)' pd='perip(1.54,sdd)' ps='perip(1.54,sdd)'
M_4_1 out in2 vdd vdd p W='1.54*1u' L=lp_min ad='areap(1.54,sdd)'
+ as='areap(1.54,sdd)' pd='perip(1.54,sdd)' ps='perip(1.54,sdd)'
M_5_1 out in2 vdd vdd p W='1.54*1u' L=lp_min ad='areap(1.54,sdd)'
+ as='areap(1.54,sdd)' pd='perip(1.54,sdd)' ps='perip(1.54,sdd)'
M_6_1 out in3 vdd vdd p W='1.54*1u' L=lp_min ad='areap(1.54,sdd)'
+ as='areap(1.54,sdd)' pd='perip(1.54,sdd)' ps='perip(1.54,sdd)'
M_7_1 out in3 vdd vdd p W='1.54*1u' L=lp_min ad='areap(1.54,sdd)'
+ as='areap(1.54,sdd)' pd='perip(1.54,sdd)' ps='perip(1.54,sdd)'
M_8_1 net_3 in3 gnd gnd n W='6.16*1u' L=ln_min ad='arean(6.16,sdd)'
+ as='arean(6.16,sdd)' pd='perin(6.16,sdd)' ps='perin(6.16,sdd)'
M_9_1 net_2 in2 net_3 gnd n W='6.16*1u' L=ln_min ad='arean(6.16,sdd)'
+ as='arean(6.16,sdd)' pd='perin(6.16,sdd)' ps='perin(6.16,sdd)'
M_10_1 net_1 in1 net_2 gnd n W='6.16*1u' L=ln_min ad='arean(6.16,sdd)'
+ as='arean(6.16,sdd)' pd='perin(6.16,sdd)' ps='perin(6.16,sdd)'
M_11_1 out in0 net_1 gnd n W='6.16*1u' L=ln_min ad='arean(6.16,sdd)'
+ as='arean(6.16,sdd)' pd='perin(6.16,sdd)' ps='perin(6.16,sdd)'
*.ENDS	$ MMI_NAND4C
