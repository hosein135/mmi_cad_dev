*** Extracted spice netlist generated from MAX ***

.SUBCKT MMI_INVB in out
C_1 vdd gnd 1.03658fF
C_2 in gnd 0.59527fF
C_3 out gnd 0.8136fF
C_4 gnd gnd 0.97046fF
Mp_1 vdd in out vdd p W=1.54U L=0.15U AD=0.6083P PD=3.87U AS=0.6083P
+ PS=3.87U
Mn_1 gnd in out gnd n W=0.77U L=0.15U AD=0.30415P PD=2.33U AS=0.30415P
+ PS=2.33U
.ENDS	$ MMI_INVB

.GLOBAL gnd vdd
