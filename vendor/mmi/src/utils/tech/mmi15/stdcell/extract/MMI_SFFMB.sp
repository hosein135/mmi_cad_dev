*** Extracted spice netlist generated from MAX ***

.SUBCKT MMI_SFFMB clk d0 d1 q s_en s_in s_out sel
C_1 net_1 gnd 3.83548fF
C_2 s_en gnd 6.23208fF
C_3 vdd gnd 7.94458fF
C_4 sel gnd 2.27538fF
C_5 net_2 gnd 2.65985fF
C_6 net_3 gnd 1.61742fF
C_7 d0 gnd 1.26938fF
C_8 net_5 gnd 3.78835fF
C_9 d1 gnd 0.88767fF
C_10 s_in gnd 1.02187fF
C_11 clk gnd 3.52987fF
C_12 net_8 gnd 2.99794fF
C_13 net_9 gnd 3.87378fF
C_14 net_10 gnd 1.96218fF
C_15 net_11 gnd 2.78066fF
C_16 net_12 gnd 4.68678fF
C_17 s_out gnd 0.959058fF
C_18 q gnd 0.932625fF
C_19 gnd gnd 6.92086fF
C_20 net_16 gnd 0.64804fF
Mp_1 net_1 s_en vdd vdd p W=0.77U L=0.15U AD=0.30415P PD=2.33U AS=0.222189P
+ PS=1.80797U
Mp_2 vdd sel net_2 vdd p W=0.77U L=0.15U AD=0.222189P PD=1.80797U
+ AS=0.30415P PS=2.33U
Mp_3 net_3 s_en vdd vdd p W=1.54U L=0.15U AD=0.479013P PD=3.2025U
+ AS=0.444378P PS=3.61595U
Mp_4 vdd s_en net_3 vdd p W=1.54U L=0.15U AD=0.444378P PD=3.61595U
+ AS=0.479013P PS=3.2025U
Mp_5 net_3 sel net_4 vdd p W=1.54U L=0.15U AD=0.479013P PD=3.2025U
+ AS=0.2464P PS=1.86U
Mp_6 net_4 d0 net_5 vdd p W=1.54U L=0.15U AD=0.2464P PD=1.86U AS=0.517633P
+ PS=3.56667U
Mp_7 net_3 net_2 net_6 vdd p W=1.54U L=0.15U AD=0.479013P PD=3.2025U
+ AS=0.2464P PS=1.86U
Mp_8 net_6 d1 net_5 vdd p W=1.54U L=0.15U AD=0.2464P PD=1.86U AS=0.517633P
+ PS=3.56667U
Mp_9 vdd s_in net_7 vdd p W=0.77U L=0.15U AD=0.222189P PD=1.80797U
+ AS=0.121275P PS=1.085U
Mp_10 net_7 net_1 net_5 vdd p W=0.77U L=0.15U AD=0.121275P PD=1.085U
+ AS=0.258817P PS=1.78333U
Mp_11 net_5 clk net_8 vdd p W=0.77U L=0.15U AD=0.258817P PD=1.78333U
+ AS=0.30415P PS=2.62625U
Mp_12 net_9 clk vdd vdd p W=0.77U L=0.15U AD=0.30415P PD=2.33U AS=0.222189P
+ PS=1.80797U
Mp_13 vdd net_8 net_10 vdd p W=0.77U L=0.15U AD=0.222189P PD=1.80797U
+ AS=0.1694P PS=1.21U
Mp_14 net_10 net_9 net_11 vdd p W=0.77U L=0.15U AD=0.1694P PD=1.21U
+ AS=0.30415P PS=2.62625U
Mp_15 net_12 net_11 vdd vdd p W=0.77U L=0.15U AD=0.30415P PD=2.33U
+ AS=0.222189P PS=1.80797U
Mp_16 vdd net_12 s_out vdd p W=0.705U L=0.15U AD=0.203433P PD=1.65535U
+ AS=0.1551P PS=1.145U
Mp_17 s_out s_en vdd vdd p W=0.705U L=0.15U AD=0.1551P PD=1.145U
+ AS=0.203433P PS=1.65535U
Mp_18 vdd net_12 net_13 vdd p W=0.35U L=0.15U AD=0.100995P PD=0.821806U
+ AS=0.055125P PS=0.665U
Mp_19 net_13 clk net_11 vdd p W=0.35U L=0.15U AD=0.055125P PD=0.665U
+ AS=0.13825P PS=1.19375U
Mp_20 vdd net_10 net_14 vdd p W=0.35U L=0.15U AD=0.100995P PD=0.821806U
+ AS=0.056P PS=0.67U
Mp_21 net_14 net_9 net_8 vdd p W=0.35U L=0.15U AD=0.056P PD=0.67U
+ AS=0.13825P PS=1.19375U
Mp_22 vdd net_12 q vdd p W=1.54U L=0.15U AD=0.444378P PD=3.61595U
+ AS=0.6083P PS=3.87U
Mn_1 net_1 s_en gnd gnd n W=0.385U L=0.15U AD=0.152075P PD=1.56U
+ AS=0.113428P PS=1.1975U
Mn_2 gnd sel net_2 gnd n W=0.385U L=0.15U AD=0.113428P PD=1.1975U
+ AS=0.152075P PS=1.56U
Mn_3 net_5 d0 net_15 gnd n W=0.77U L=0.15U AD=0.264406P PD=2.67723U
+ AS=0.1232P PS=1.09U
Mn_4 net_15 net_2 net_16 gnd n W=0.77U L=0.15U AD=0.1232P PD=1.09U
+ AS=0.176525P PS=1.6225U
Mn_5 s_out net_12 net_17 gnd n W=0.705U L=0.15U AD=0.278475P PD=2.2U
+ AS=0.111037P PS=1.02U
Mn_6 net_17 s_en gnd gnd n W=0.705U L=0.15U AD=0.111037P PD=1.02U
+ AS=0.207706P PS=2.19282U
Mn_7 net_16 net_1 gnd gnd n W=0.77U L=0.15U AD=0.176525P PD=1.6225U
+ AS=0.226856P PS=2.395U
Mn_8 gnd net_1 net_16 gnd n W=0.77U L=0.15U AD=0.226856P PD=2.395U
+ AS=0.176525P PS=1.6225U
Mn_9 net_16 sel net_18 gnd n W=0.77U L=0.15U AD=0.176525P PD=1.6225U
+ AS=0.11935P PS=1.08U
Mn_10 net_18 d1 net_5 gnd n W=0.77U L=0.15U AD=0.11935P PD=1.08U
+ AS=0.264406P PS=2.67723U
Mn_11 gnd net_12 q gnd n W=0.77U L=0.15U AD=0.226856P PD=2.395U AS=0.30415P
+ PS=2.33U
Mn_12 net_5 s_en net_19 gnd n W=0.385U L=0.15U AD=0.132203P PD=1.33862U
+ AS=0.0616P PS=0.705U
Mn_13 net_19 s_in gnd gnd n W=0.385U L=0.15U AD=0.0616P PD=0.705U
+ AS=0.113428P PS=1.1975U
Mn_14 net_5 net_9 net_8 gnd n W=0.35U L=0.15U AD=0.120185P PD=1.21692U
+ AS=0.13825P PS=1.49U
Mn_15 net_9 clk gnd gnd n W=0.385U L=0.15U AD=0.152075P PD=1.56U
+ AS=0.113428P PS=1.1975U
Mn_16 net_8 clk net_20 gnd n W=0.35U L=0.15U AD=0.13825P PD=1.49U
+ AS=0.055125P PS=0.665U
Mn_17 net_20 net_10 gnd gnd n W=0.35U L=0.15U AD=0.055125P PD=0.665U
+ AS=0.103116P PS=1.08864U
Mn_18 gnd net_8 net_10 gnd n W=0.385U L=0.15U AD=0.113428P PD=1.1975U
+ AS=0.0952417P PS=1.73381U
Mn_19 net_10 clk net_11 gnd n W=0.35U L=0.15U AD=0.0865833P PD=1.57619U
+ AS=0.13825P PS=1.49U
Mn_20 gnd net_11 net_12 gnd n W=0.52U L=0.15U AD=0.153202P PD=1.6174U
+ AS=0.2054P PS=1.83U
Mn_21 net_11 net_9 net_21 gnd n W=0.35U L=0.15U AD=0.13825P PD=1.49U
+ AS=0.056P PS=0.67U
Mn_22 net_21 net_12 gnd gnd n W=0.35U L=0.15U AD=0.056P PD=0.67U
+ AS=0.103116P PS=1.08864U
.ENDS	$ MMI_SFFMB

.GLOBAL gnd vdd
