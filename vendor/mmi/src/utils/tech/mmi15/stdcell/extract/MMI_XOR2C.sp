*** Extracted spice netlist generated from MAX ***

.SUBCKT MMI_XOR2C in0 in1 out
C_1 out gnd 2.34975fF
C_2 net_1 gnd 3.50124fF
C_3 net_2 gnd 3.05732fF
C_4 in1 gnd 3.29107fF
C_5 vdd gnd 4.7672fF
C_6 in0 gnd 2.7791fF
C_7 gnd gnd 4.2314fF
C_8 net_5 gnd 0.98898fF
Mp_1 out net_1 net_2 vdd p W=2.055U L=0.15U AD=0.571975P PD=3.29667U
+ AS=0.492058P PS=2.76222U
Mp_2 net_2 net_1 out vdd p W=2.055U L=0.15U AD=0.492058P PD=2.76222U
+ AS=0.571975P PS=3.29667U
Mp_3 out net_1 net_2 vdd p W=2.055U L=0.15U AD=0.571975P PD=3.29667U
+ AS=0.492058P PS=2.76222U
Mp_4 net_2 in1 vdd vdd p W=2.055U L=0.15U AD=0.492058P PD=2.76222U
+ AS=0.523978P PS=3.02849U
Mp_5 vdd in1 net_2 vdd p W=2.055U L=0.15U AD=0.523978P PD=3.02849U
+ AS=0.492058P PS=2.76222U
Mp_6 net_2 in1 vdd vdd p W=2.055U L=0.15U AD=0.492058P PD=2.76222U
+ AS=0.523978P PS=3.02849U
Mp_7 vdd in0 net_2 vdd p W=2.055U L=0.15U AD=0.523978P PD=3.02849U
+ AS=0.492058P PS=2.76222U
Mp_8 net_2 in0 vdd vdd p W=2.055U L=0.15U AD=0.492058P PD=2.76222U
+ AS=0.523978P PS=3.02849U
Mp_9 vdd in0 net_2 vdd p W=2.055U L=0.15U AD=0.523978P PD=3.02849U
+ AS=0.492058P PS=2.76222U
Mp_10 vdd in1 net_3 vdd p W=1.54U L=0.15U AD=0.392665P PD=2.26953U
+ AS=0.2464P PS=1.86U
Mp_11 net_3 in0 net_1 vdd p W=1.54U L=0.15U AD=0.2464P PD=1.86U AS=0.3388P
+ PS=1.98U
Mp_12 net_1 in0 net_4 vdd p W=1.54U L=0.15U AD=0.3388P PD=1.98U AS=0.2464P
+ PS=1.86U
Mp_13 net_4 in1 vdd vdd p W=1.54U L=0.15U AD=0.2464P PD=1.86U AS=0.392665P
+ PS=2.26953U
Mn_1 out net_1 gnd gnd n W=0.77U L=0.15U AD=0.205109P PD=1.5133U
+ AS=0.225555P PS=1.60755U
Mn_2 gnd net_1 out gnd n W=0.77U L=0.15U AD=0.225555P PD=1.60755U
+ AS=0.205109P PS=1.5133U
Mn_3 out in1 net_5 gnd n W=1.025U L=0.15U AD=0.273035P PD=2.01446U
+ AS=0.2255P PS=1.465U
Mn_4 net_5 in1 out gnd n W=1.025U L=0.15U AD=0.2255P PD=1.465U AS=0.273035P
+ PS=2.01446U
Mn_5 out in1 net_5 gnd n W=1.025U L=0.15U AD=0.273035P PD=2.01446U
+ AS=0.2255P PS=1.465U
Mn_6 net_5 in0 gnd gnd n W=1.025U L=0.15U AD=0.2255P PD=1.465U AS=0.300252P
+ PS=2.13993U
Mn_7 gnd in0 net_5 gnd n W=1.025U L=0.15U AD=0.300252P PD=2.13993U
+ AS=0.2255P PS=1.465U
Mn_8 net_5 in0 gnd gnd n W=1.025U L=0.15U AD=0.2255P PD=1.465U AS=0.300252P
+ PS=2.13993U
Mn_9 gnd in1 net_1 gnd n W=0.77U L=0.15U AD=0.225555P PD=1.60755U
+ AS=0.186725P PS=1.255U
Mn_10 net_1 in0 gnd gnd n W=0.77U L=0.15U AD=0.186725P PD=1.255U
+ AS=0.225555P PS=1.60755U
.ENDS	$ MMI_XOR2C

.GLOBAL gnd vdd
