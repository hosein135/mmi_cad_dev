*** Extracted spice netlist generated from MAX ***

.SUBCKT MMI_AOI21C in0 in1 in2 out
C_1 out gnd 2.26887fF
C_2 in0 gnd 1.20445fF
C_3 net_1 gnd 3.05951fF
C_4 in1 gnd 1.32391fF
C_5 vdd gnd 3.11554fF
C_6 in2 gnd 1.32456fF
C_7 gnd gnd 2.99926fF
C_8 net_2 gnd 0.998705fF
Mp_1 out in0 net_1 vdd p W=2.055U L=0.15U AD=0.571975P PD=3.29667U
+ AS=0.492058P PS=2.76222U
Mp_2 net_1 in0 out vdd p W=2.055U L=0.15U AD=0.492058P PD=2.76222U
+ AS=0.571975P PS=3.29667U
Mp_3 out in0 net_1 vdd p W=2.055U L=0.15U AD=0.571975P PD=3.29667U
+ AS=0.492058P PS=2.76222U
Mp_4 net_1 in1 vdd vdd p W=2.055U L=0.15U AD=0.492058P PD=2.76222U
+ AS=0.4521P PS=2.495U
Mp_5 vdd in1 net_1 vdd p W=2.055U L=0.15U AD=0.4521P PD=2.495U AS=0.492058P
+ PS=2.76222U
Mp_6 net_1 in1 vdd vdd p W=2.055U L=0.15U AD=0.492058P PD=2.76222U
+ AS=0.4521P PS=2.495U
Mp_7 vdd in2 net_1 vdd p W=2.055U L=0.15U AD=0.4521P PD=2.495U AS=0.492058P
+ PS=2.76222U
Mp_8 net_1 in2 vdd vdd p W=2.055U L=0.15U AD=0.492058P PD=2.76222U
+ AS=0.4521P PS=2.495U
Mp_9 vdd in2 net_1 vdd p W=2.055U L=0.15U AD=0.4521P PD=2.495U AS=0.492058P
+ PS=2.76222U
Mn_1 out in0 gnd gnd n W=0.77U L=0.15U AD=0.207037P PD=1.51831U
+ AS=0.199328P PS=1.36648U
Mn_2 gnd in0 out gnd n W=0.77U L=0.15U AD=0.199328P PD=1.36648U
+ AS=0.207037P PS=1.51831U
Mn_3 out in1 net_2 gnd n W=1.025U L=0.15U AD=0.275601P PD=2.02113U
+ AS=0.234896P PS=1.48333U
Mn_4 net_2 in1 out gnd n W=1.025U L=0.15U AD=0.234896P PD=1.48333U
+ AS=0.275601P PS=2.02113U
Mn_5 out in1 net_2 gnd n W=1.025U L=0.15U AD=0.275601P PD=2.02113U
+ AS=0.234896P PS=1.48333U
Mn_6 net_2 in2 gnd gnd n W=1.025U L=0.15U AD=0.234896P PD=1.48333U
+ AS=0.26534P PS=1.81901U
Mn_7 gnd in2 net_2 gnd n W=1.025U L=0.15U AD=0.26534P PD=1.81901U
+ AS=0.234896P PS=1.48333U
Mn_8 net_2 in2 gnd gnd n W=1.025U L=0.15U AD=0.234896P PD=1.48333U
+ AS=0.26534P PS=1.81901U
.ENDS	$ MMI_AOI21C

.GLOBAL gnd vdd
