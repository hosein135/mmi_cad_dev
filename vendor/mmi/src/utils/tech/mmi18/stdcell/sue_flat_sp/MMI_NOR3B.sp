* FILE: MMI_NOR3B.sp

* SPICE netlist for "MMI_NOR3B" (generated by MMI_SUE4.2.1)

*.SUBCKT MMI_NOR3B in0 in1 in2 out
M_0 out in0 gnd gnd n W='0.92*1u' L=ln_min ad='arean(0.92,sdd)'
+ as='arean(0.92,sdd)' pd='perin(0.92,sdd)' ps='perin(0.92,sdd)'
M_1_1 out in1 gnd gnd n W='0.92*1u' L=ln_min ad='arean(0.92,sdd)'
+ as='arean(0.92,sdd)' pd='perin(0.92,sdd)' ps='perin(0.92,sdd)'
M_2_1 out in2 gnd gnd n W='0.92*1u' L=ln_min ad='arean(0.92,sdd)'
+ as='arean(0.92,sdd)' pd='perin(0.92,sdd)' ps='perin(0.92,sdd)'
M_3_1 out in0 net_1 vdd p W='1.84*1u' L=lp_min ad='areap(1.84,sdd)'
+ as='areap(1.84,sdd)' pd='perip(1.84,sdd)' ps='perip(1.84,sdd)'
M_4_1 out in0 net_2 vdd p W='1.84*1u' L=lp_min ad='areap(1.84,sdd)'
+ as='areap(1.84,sdd)' pd='perip(1.84,sdd)' ps='perip(1.84,sdd)'
M_5_1 out in0 net_3 vdd p W='1.84*1u' L=lp_min ad='areap(1.84,sdd)'
+ as='areap(1.84,sdd)' pd='perip(1.84,sdd)' ps='perip(1.84,sdd)'
M_6_1 net_1 in1 net_4 vdd p W='1.84*1u' L=lp_min ad='areap(1.84,sdd)'
+ as='areap(1.84,sdd)' pd='perip(1.84,sdd)' ps='perip(1.84,sdd)'
M_7_1 net_2 in1 net_5 vdd p W='1.84*1u' L=lp_min ad='areap(1.84,sdd)'
+ as='areap(1.84,sdd)' pd='perip(1.84,sdd)' ps='perip(1.84,sdd)'
M_8_1 net_3 in1 net_6 vdd p W='1.84*1u' L=lp_min ad='areap(1.84,sdd)'
+ as='areap(1.84,sdd)' pd='perip(1.84,sdd)' ps='perip(1.84,sdd)'
M_9_1 net_4 in2 vdd vdd p W='1.84*1u' L=lp_min ad='areap(1.84,sdd)'
+ as='areap(1.84,sdd)' pd='perip(1.84,sdd)' ps='perip(1.84,sdd)'
M_10_1 net_5 in2 vdd vdd p W='1.84*1u' L=lp_min ad='areap(1.84,sdd)'
+ as='areap(1.84,sdd)' pd='perip(1.84,sdd)' ps='perip(1.84,sdd)'
M_11_1 net_6 in2 vdd vdd p W='1.84*1u' L=lp_min ad='areap(1.84,sdd)'
+ as='areap(1.84,sdd)' pd='perip(1.84,sdd)' ps='perip(1.84,sdd)'
*.ENDS	$ MMI_NOR3B
