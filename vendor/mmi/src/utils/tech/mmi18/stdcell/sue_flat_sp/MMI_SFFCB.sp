* FILE: MMI_SFFCB.sp

* SPICE netlist for "MMI_SFFCB" (generated by MMI_SUE4.2.1)

*.SUBCKT MMI_SFFCB clk clrb d q s_en s_in s_out
Minverter._0 scan_en_L s_en gnd gnd n W='0.6*1u' L=ln_min
+ ad='arean(0.6,sdd)' as='arean(0.6,sdd)' pd='perin(0.6,sdd)'
+ ps='perin(0.6,sdd)'
Minverter._1 scan_en_L s_en vdd vdd p W='1.2*1u' L=lp_min
+ ad='areap(1.2,sdd)' as='areap(1.2,sdd)' pd='perip(1.2,sdd)'
+ ps='perip(1.2,sdd)'
Minverter_1._2 q N5 gnd gnd n W='0.92*1u' L=ln_min ad='arean(0.92,sdd)'
+ as='arean(0.92,sdd)' pd='perin(0.92,sdd)' ps='perin(0.92,sdd)'
Minverter_1._3 q N5 vdd vdd p W='1.84*1u' L=lp_min ad='areap(1.84,sdd)'
+ as='areap(1.84,sdd)' pd='perip(1.84,sdd)' ps='perip(1.84,sdd)'
M_4_1 N1 d net_1 vdd p W='1.84*1u' L=lp_min ad='areap(1.84,sdd)'
+ as='areap(1.84,sdd)' pd='perip(1.84,sdd)' ps='perip(1.84,sdd)'
M_5_1 net_1 s_en vdd vdd p W='1.84*1u' L=lp_min ad='areap(1.84,sdd)'
+ as='areap(1.84,sdd)' pd='perip(1.84,sdd)' ps='perip(1.84,sdd)'
M_6_1 net_2 scan_en_L gnd gnd n W='0.92*1u' L=ln_min ad='arean(0.92,sdd)'
+ as='arean(0.92,sdd)' pd='perin(0.92,sdd)' ps='perin(0.92,sdd)'
M_7_1 N1 d net_2 gnd n W='0.92*1u' L=ln_min ad='arean(0.92,sdd)'
+ as='arean(0.92,sdd)' pd='perin(0.92,sdd)' ps='perin(0.92,sdd)'
Minverter_2._8 clk_L clk gnd gnd n W='0.46*1u' L=ln_min
+ ad='arean(0.46,sdd)' as='arean(0.46,sdd)' pd='perin(0.46,sdd)'
+ ps='perin(0.46,sdd)'
Minverter_2._9 clk_L clk vdd vdd p W='0.92*1u' L=lp_min
+ ad='areap(0.92,sdd)' as='areap(0.92,sdd)' pd='perip(0.92,sdd)'
+ ps='perip(0.92,sdd)'
M_10_1 N1 scan_en_L net_3 vdd p W='0.92*1u' L=lp_min ad='areap(0.92,sdd)'
+ as='areap(0.92,sdd)' pd='perip(0.92,sdd)' ps='perip(0.92,sdd)'
M_11_1 N1 s_en net_4 gnd n W='0.46*1u' L=ln_min ad='arean(0.46,sdd)'
+ as='arean(0.46,sdd)' pd='perin(0.46,sdd)' ps='perin(0.46,sdd)'
M_12_1 net_4 s_in gnd gnd n W='0.46*1u' L=ln_min ad='arean(0.46,sdd)'
+ as='arean(0.46,sdd)' pd='perin(0.46,sdd)' ps='perin(0.46,sdd)'
M_13_1 net_3 s_in vdd vdd p W='0.92*1u' L=lp_min ad='areap(0.92,sdd)'
+ as='areap(0.92,sdd)' pd='perip(0.92,sdd)' ps='perip(0.92,sdd)'
M_14_1 net_5 N5 gnd gnd n W='0.42*1u' L=ln_min ad='arean(0.42,sdd)'
+ as='arean(0.42,sdd)' pd='perin(0.42,sdd)' ps='perin(0.42,sdd)'
M_15_1 N4 clk net_6 vdd p W='0.42*1u' L=lp_min ad='areap(0.42,sdd)'
+ as='areap(0.42,sdd)' pd='perip(0.42,sdd)' ps='perip(0.42,sdd)'
M_16_1 N4 clk_L net_5 gnd n W='0.42*1u' L=ln_min ad='arean(0.42,sdd)'
+ as='arean(0.42,sdd)' pd='perin(0.42,sdd)' ps='perin(0.42,sdd)'
M_17_1 net_6 N5 vdd vdd p W='0.42*1u' L=lp_min ad='areap(0.42,sdd)'
+ as='areap(0.42,sdd)' pd='perip(0.42,sdd)' ps='perip(0.42,sdd)'
M_18_1 net_7 N3 vdd vdd p W='0.42*1u' L=lp_min ad='areap(0.42,sdd)'
+ as='areap(0.42,sdd)' pd='perip(0.42,sdd)' ps='perip(0.42,sdd)'
M_19_1 N2 clk_L net_7 vdd p W='0.42*1u' L=lp_min ad='areap(0.42,sdd)'
+ as='areap(0.42,sdd)' pd='perip(0.42,sdd)' ps='perip(0.42,sdd)'
M_20_1 N2 clk net_8 gnd n W='0.42*1u' L=ln_min ad='arean(0.42,sdd)'
+ as='arean(0.42,sdd)' pd='perin(0.42,sdd)' ps='perin(0.42,sdd)'
M_21_1 net_8 N3 gnd gnd n W='0.42*1u' L=ln_min ad='arean(0.42,sdd)'
+ as='arean(0.42,sdd)' pd='perin(0.42,sdd)' ps='perin(0.42,sdd)'
Mxgate._22 N4 clk_L N3 vdd p W='0.92*1u' L=lp_min ad='areap(0.92,sdd)'
+ as='areap(0.92,sdd)' pd='perip(0.92,sdd)' ps='perip(0.92,sdd)'
Mxgate._23 N4 clk N3 gnd n W='0.42*1u' L=ln_min ad='arean(0.42,sdd)'
+ as='arean(0.42,sdd)' pd='perin(0.42,sdd)' ps='perin(0.42,sdd)'
Mxgate_1._24 N1 clk N2 vdd p W='0.92*1u' L=lp_min ad='areap(0.92,sdd)'
+ as='areap(0.92,sdd)' pd='perip(0.92,sdd)' ps='perip(0.92,sdd)'
Mxgate_1._25 N1 clk_L N2 gnd n W='0.42*1u' L=ln_min ad='arean(0.42,sdd)'
+ as='arean(0.42,sdd)' pd='perin(0.42,sdd)' ps='perin(0.42,sdd)'
Minverter_3._26 clear clrb gnd gnd n W='0.6*1u' L=ln_min
+ ad='arean(0.6,sdd)' as='arean(0.6,sdd)' pd='perin(0.6,sdd)'
+ ps='perin(0.6,sdd)'
Minverter_3._27 clear clrb vdd vdd p W='1.2*1u' L=lp_min
+ ad='areap(1.2,sdd)' as='areap(1.2,sdd)' pd='perip(1.2,sdd)'
+ ps='perip(1.2,sdd)'
Mnand2._28 N5 N4 vdd vdd p W='0.92*1u' L=lp_min ad='areap(0.92,sdd)'
+ as='areap(0.92,sdd)' pd='perip(0.92,sdd)' ps='perip(0.92,sdd)'
Mnand2._29 N5 N4 nand2%net_1 gnd n W='1.24*1u' L=ln_min
+ ad='arean(1.24,sdd)' as='arean(1.24,sdd)' pd='perin(1.24,sdd)'
+ ps='perin(1.24,sdd)'
Mnand2._30 N5 clrb vdd vdd p W='0.92*1u' L=lp_min ad='areap(0.92,sdd)'
+ as='areap(0.92,sdd)' pd='perip(0.92,sdd)' ps='perip(0.92,sdd)'
Mnand2._31 nand2%net_1 clrb gnd gnd n W='1.24*1u' L=ln_min
+ ad='arean(1.24,sdd)' as='arean(1.24,sdd)' pd='perin(1.24,sdd)'
+ ps='perin(1.24,sdd)'
Mnor2._32 N3 N2 gnd gnd n W='0.46*1u' L=ln_min ad='arean(0.46,sdd)'
+ as='arean(0.46,sdd)' pd='perin(0.46,sdd)' ps='perin(0.46,sdd)'
Mnor2._33 N3 N2 nor2%net_1 vdd p W='1.84*1u' L=lp_min ad='areap(1.84,sdd)'
+ as='areap(1.84,sdd)' pd='perip(1.84,sdd)' ps='perip(1.84,sdd)'
Mnor2._34 N3 clear gnd gnd n W='0.46*1u' L=ln_min ad='arean(0.46,sdd)'
+ as='arean(0.46,sdd)' pd='perin(0.46,sdd)' ps='perin(0.46,sdd)'
Mnor2._35 nor2%net_1 clear vdd vdd p W='1.84*1u' L=lp_min
+ ad='areap(1.84,sdd)' as='areap(1.84,sdd)' pd='perip(1.84,sdd)'
+ ps='perip(1.84,sdd)'
Mnand2_1._36 s_out N5 vdd vdd p W='0.84*1u' L=lp_min ad='areap(0.84,sdd)'
+ as='areap(0.84,sdd)' pd='perip(0.84,sdd)' ps='perip(0.84,sdd)'
Mnand2_1._37 s_out N5 nand2_1%net_1 gnd n W='0.84*1u' L=ln_min
+ ad='arean(0.84,sdd)' as='arean(0.84,sdd)' pd='perin(0.84,sdd)'
+ ps='perin(0.84,sdd)'
Mnand2_1._38 s_out s_en vdd vdd p W='0.84*1u' L=lp_min ad='areap(0.84,sdd)'
+ as='areap(0.84,sdd)' pd='perip(0.84,sdd)' ps='perip(0.84,sdd)'
Mnand2_1._39 nand2_1%net_1 s_en gnd gnd n W='0.84*1u' L=ln_min
+ ad='arean(0.84,sdd)' as='arean(0.84,sdd)' pd='perin(0.84,sdd)'
+ ps='perin(0.84,sdd)'
.ic N4=0V
*.ENDS	$ MMI_SFFCB
