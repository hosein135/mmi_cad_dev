* FILE: MMI_SFFHB.sp

* SPICE netlist for "MMI_SFFHB" (generated by MMI_SUE4.2.1)

*.SUBCKT MMI_SFFHB clk d hold q s_en s_in s_out
Minverter._0 q N5 gnd gnd n W='0.92*1u' L=ln_min ad='arean(0.92,sdd)'
+ as='arean(0.92,sdd)' pd='perin(0.92,sdd)' ps='perin(0.92,sdd)'
Minverter._1 q N5 vdd vdd p W='1.84*1u' L=lp_min ad='areap(1.84,sdd)'
+ as='areap(1.84,sdd)' pd='perip(1.84,sdd)' ps='perip(1.84,sdd)'
M_2_1 N1 d net_1 vdd p W='1.84*1u' L=lp_min ad='areap(1.84,sdd)'
+ as='areap(1.84,sdd)' pd='perip(1.84,sdd)' ps='perip(1.84,sdd)'
M_3_1 N1 d net_2 gnd n W='0.92*1u' L=ln_min ad='arean(0.92,sdd)'
+ as='arean(0.92,sdd)' pd='perin(0.92,sdd)' ps='perin(0.92,sdd)'
Minverter_1._4 clk_L clk gnd gnd n W='0.46*1u' L=ln_min
+ ad='arean(0.46,sdd)' as='arean(0.46,sdd)' pd='perin(0.46,sdd)'
+ ps='perin(0.46,sdd)'
Minverter_1._5 clk_L clk vdd vdd p W='0.92*1u' L=lp_min
+ ad='areap(0.92,sdd)' as='areap(0.92,sdd)' pd='perip(0.92,sdd)'
+ ps='perip(0.92,sdd)'
M_6_1 N1 s_en_L net_3 vdd p W='0.92*1u' L=lp_min ad='areap(0.92,sdd)'
+ as='areap(0.92,sdd)' pd='perip(0.92,sdd)' ps='perip(0.92,sdd)'
M_7_1 N1 s_en net_4 gnd n W='0.46*1u' L=ln_min ad='arean(0.46,sdd)'
+ as='arean(0.46,sdd)' pd='perin(0.46,sdd)' ps='perin(0.46,sdd)'
M_8_1 net_4 s_in gnd gnd n W='0.46*1u' L=ln_min ad='arean(0.46,sdd)'
+ as='arean(0.46,sdd)' pd='perin(0.46,sdd)' ps='perin(0.46,sdd)'
M_9_1 net_3 s_in vdd vdd p W='0.92*1u' L=lp_min ad='areap(0.92,sdd)'
+ as='areap(0.92,sdd)' pd='perip(0.92,sdd)' ps='perip(0.92,sdd)'
M_10_1 net_5 N5 gnd gnd n W='0.42*1u' L=ln_min ad='arean(0.42,sdd)'
+ as='arean(0.42,sdd)' pd='perin(0.42,sdd)' ps='perin(0.42,sdd)'
M_11_1 N4 clk net_6 vdd p W='0.42*1u' L=lp_min ad='areap(0.42,sdd)'
+ as='areap(0.42,sdd)' pd='perip(0.42,sdd)' ps='perip(0.42,sdd)'
M_12_1 N4 clk_L net_5 gnd n W='0.42*1u' L=ln_min ad='arean(0.42,sdd)'
+ as='arean(0.42,sdd)' pd='perin(0.42,sdd)' ps='perin(0.42,sdd)'
M_13_1 net_6 N5 vdd vdd p W='0.42*1u' L=lp_min ad='areap(0.42,sdd)'
+ as='areap(0.42,sdd)' pd='perip(0.42,sdd)' ps='perip(0.42,sdd)'
M_14_1 net_7 N3 vdd vdd p W='0.42*1u' L=lp_min ad='areap(0.42,sdd)'
+ as='areap(0.42,sdd)' pd='perip(0.42,sdd)' ps='perip(0.42,sdd)'
M_15_1 N2 clk_L net_7 vdd p W='0.42*1u' L=lp_min ad='areap(0.42,sdd)'
+ as='areap(0.42,sdd)' pd='perip(0.42,sdd)' ps='perip(0.42,sdd)'
M_16_1 N2 clk net_8 gnd n W='0.42*1u' L=ln_min ad='arean(0.42,sdd)'
+ as='arean(0.42,sdd)' pd='perin(0.42,sdd)' ps='perin(0.42,sdd)'
M_17_1 net_8 N3 gnd gnd n W='0.42*1u' L=ln_min ad='arean(0.42,sdd)'
+ as='arean(0.42,sdd)' pd='perin(0.42,sdd)' ps='perin(0.42,sdd)'
Mxgate._18 N4 clk_L N3 vdd p W='0.92*1u' L=lp_min ad='areap(0.92,sdd)'
+ as='areap(0.92,sdd)' pd='perip(0.92,sdd)' ps='perip(0.92,sdd)'
Mxgate._19 N4 clk N3 gnd n W='0.42*1u' L=ln_min ad='arean(0.42,sdd)'
+ as='arean(0.42,sdd)' pd='perin(0.42,sdd)' ps='perin(0.42,sdd)'
Mxgate_1._20 N1 clk N2 vdd p W='0.92*1u' L=lp_min ad='areap(0.92,sdd)'
+ as='areap(0.92,sdd)' pd='perip(0.92,sdd)' ps='perip(0.92,sdd)'
Mxgate_1._21 N1 clk_L N2 gnd n W='0.42*1u' L=ln_min ad='arean(0.42,sdd)'
+ as='arean(0.42,sdd)' pd='perin(0.42,sdd)' ps='perin(0.42,sdd)'
Mnand2._22 s_out N5 vdd vdd p W='0.84*1u' L=lp_min ad='areap(0.84,sdd)'
+ as='areap(0.84,sdd)' pd='perip(0.84,sdd)' ps='perip(0.84,sdd)'
Mnand2._23 s_out N5 nand2%net_1 gnd n W='0.84*1u' L=ln_min
+ ad='arean(0.84,sdd)' as='arean(0.84,sdd)' pd='perin(0.84,sdd)'
+ ps='perin(0.84,sdd)'
Mnand2._24 s_out s_en vdd vdd p W='0.84*1u' L=lp_min ad='areap(0.84,sdd)'
+ as='areap(0.84,sdd)' pd='perip(0.84,sdd)' ps='perip(0.84,sdd)'
Mnand2._25 nand2%net_1 s_en gnd gnd n W='0.84*1u' L=ln_min
+ ad='arean(0.84,sdd)' as='arean(0.84,sdd)' pd='perin(0.84,sdd)'
+ ps='perin(0.84,sdd)'
Minverter_2._26 N5 N4 gnd gnd n W='0.62*1u' L=ln_min ad='arean(0.62,sdd)'
+ as='arean(0.62,sdd)' pd='perin(0.62,sdd)' ps='perin(0.62,sdd)'
Minverter_2._27 N5 N4 vdd vdd p W='0.92*1u' L=lp_min ad='areap(0.92,sdd)'
+ as='areap(0.92,sdd)' pd='perip(0.92,sdd)' ps='perip(0.92,sdd)'
Minverter_3._28 N3 N2 gnd gnd n W='0.46*1u' L=ln_min ad='arean(0.46,sdd)'
+ as='arean(0.46,sdd)' pd='perin(0.46,sdd)' ps='perin(0.46,sdd)'
Minverter_3._29 N3 N2 vdd vdd p W='0.92*1u' L=lp_min ad='areap(0.92,sdd)'
+ as='areap(0.92,sdd)' pd='perip(0.92,sdd)' ps='perip(0.92,sdd)'
M_30_1 net_1 hold net_9 vdd p W='1.84*1u' L=lp_min ad='areap(1.84,sdd)'
+ as='areap(1.84,sdd)' pd='perip(1.84,sdd)' ps='perip(1.84,sdd)'
M_31_1 N1 hold_L net_10 vdd p W='1.84*1u' L=lp_min ad='areap(1.84,sdd)'
+ as='areap(1.84,sdd)' pd='perip(1.84,sdd)' ps='perip(1.84,sdd)'
M_32_1 net_10 q_fb net_9 vdd p W='1.84*1u' L=lp_min ad='areap(1.84,sdd)'
+ as='areap(1.84,sdd)' pd='perip(1.84,sdd)' ps='perip(1.84,sdd)'
M_33_1 net_2 hold_L net_11 gnd n W='0.92*1u' L=ln_min ad='arean(0.92,sdd)'
+ as='arean(0.92,sdd)' pd='perin(0.92,sdd)' ps='perin(0.92,sdd)'
M_34_1 net_12 hold net_11 gnd n W='0.92*1u' L=ln_min ad='arean(0.92,sdd)'
+ as='arean(0.92,sdd)' pd='perin(0.92,sdd)' ps='perin(0.92,sdd)'
M_35_1 N1 q_fb net_12 gnd n W='0.92*1u' L=ln_min ad='arean(0.92,sdd)'
+ as='arean(0.92,sdd)' pd='perin(0.92,sdd)' ps='perin(0.92,sdd)'
Minverter_4._36 q_fb N5 gnd gnd n W='0.46*1u' L=ln_min ad='arean(0.46,sdd)'
+ as='arean(0.46,sdd)' pd='perin(0.46,sdd)' ps='perin(0.46,sdd)'
Minverter_4._37 q_fb N5 vdd vdd p W='0.92*1u' L=lp_min ad='areap(0.92,sdd)'
+ as='areap(0.92,sdd)' pd='perip(0.92,sdd)' ps='perip(0.92,sdd)'
M_38_1 net_9 s_en vdd vdd p W='3.68*1u' L=lp_min ad='areap(3.68,sdd)'
+ as='areap(3.68,sdd)' pd='perip(3.68,sdd)' ps='perip(3.68,sdd)'
M_39_1 net_11 s_en_L gnd gnd n W='1.84*1u' L=ln_min ad='arean(1.84,sdd)'
+ as='arean(1.84,sdd)' pd='perin(1.84,sdd)' ps='perin(1.84,sdd)'
Minverter_5._40 s_en_L s_en gnd gnd n W='0.46*1u' L=ln_min
+ ad='arean(0.46,sdd)' as='arean(0.46,sdd)' pd='perin(0.46,sdd)'
+ ps='perin(0.46,sdd)'
Minverter_5._41 s_en_L s_en vdd vdd p W='0.92*1u' L=lp_min
+ ad='areap(0.92,sdd)' as='areap(0.92,sdd)' pd='perip(0.92,sdd)'
+ ps='perip(0.92,sdd)'
Minverter_6._42 hold_L hold gnd gnd n W='0.46*1u' L=ln_min
+ ad='arean(0.46,sdd)' as='arean(0.46,sdd)' pd='perin(0.46,sdd)'
+ ps='perin(0.46,sdd)'
Minverter_6._43 hold_L hold vdd vdd p W='0.92*1u' L=lp_min
+ ad='areap(0.92,sdd)' as='areap(0.92,sdd)' pd='perip(0.92,sdd)'
+ ps='perip(0.92,sdd)'
.ic N4=0V
*.ENDS	$ MMI_SFFHB
