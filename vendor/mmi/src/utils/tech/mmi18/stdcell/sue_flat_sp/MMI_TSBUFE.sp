* FILE: MMI_TSBUFE.sp

* SPICE netlist for "MMI_TSBUFE" (generated by MMI_SUE4.2.1)

*.SUBCKT MMI_TSBUFE en enb in out
M_0 out N2 vdd vdd p W='14.72*1u' L=lp_min ad='areap(14.72,sdd)'
+ as='areap(14.72,sdd)' pd='perip(14.72,sdd)' ps='perip(14.72,sdd)'
M_1_1 out N1 gnd gnd n W='7.36*1u' L=ln_min ad='arean(7.36,sdd)'
+ as='arean(7.36,sdd)' pd='perin(7.36,sdd)' ps='perin(7.36,sdd)'
M_2_1 N1 in gnd gnd n W='2.48*1u' L=ln_min ad='arean(2.48,sdd)'
+ as='arean(2.48,sdd)' pd='perin(2.48,sdd)' ps='perin(2.48,sdd)'
M_3_1 N1 enb gnd gnd n W='1.24*1u' L=ln_min ad='arean(1.24,sdd)'
+ as='arean(1.24,sdd)' pd='perin(1.24,sdd)' ps='perin(1.24,sdd)'
M_4_1 N2 en vdd vdd p W='2*1u' L=lp_min ad='areap(2,sdd)' as='areap(2,sdd)'
+ pd='perip(2,sdd)' ps='perip(2,sdd)'
M_5_1 N1 enb N2 vdd p W='2*1u' L=lp_min ad='areap(2,sdd)' as='areap(2,sdd)'
+ pd='perip(2,sdd)' ps='perip(2,sdd)'
M_6_1 N2 in vdd vdd p W='4*1u' L=lp_min ad='areap(4,sdd)' as='areap(4,sdd)'
+ pd='perip(4,sdd)' ps='perip(4,sdd)'
M_7_1 N2 en N1 gnd n W='1.24*1u' L=ln_min ad='arean(1.24,sdd)'
+ as='arean(1.24,sdd)' pd='perin(1.24,sdd)' ps='perin(1.24,sdd)'
*.ENDS	$ MMI_TSBUFE
