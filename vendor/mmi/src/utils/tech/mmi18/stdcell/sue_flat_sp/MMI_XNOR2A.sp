* FILE: MMI_XNOR2A.sp

* SPICE netlist for "MMI_XNOR2A" (generated by MMI_SUE4.2.1)

*.SUBCKT MMI_XNOR2A in0 in1 out
MMMI_NAND2A._0 MMI_NAND2A%net_1 in1 gnd gnd n W='0.92*1u' L=ln_min
+ ad='arean(0.92,sdd)' as='arean(0.92,sdd)' pd='perin(0.92,sdd)'
+ ps='perin(0.92,sdd)'
MMMI_NAND2A._1 net_1 in0 MMI_NAND2A%net_1 gnd n W='0.92*1u' L=ln_min
+ ad='arean(0.92,sdd)' as='arean(0.92,sdd)' pd='perin(0.92,sdd)'
+ ps='perin(0.92,sdd)'
MMMI_NAND2A._2 net_1 in1 vdd vdd p W='0.92*1u' L=lp_min
+ ad='areap(0.92,sdd)' as='areap(0.92,sdd)' pd='perip(0.92,sdd)'
+ ps='perip(0.92,sdd)'
MMMI_NAND2A._3 net_1 in0 vdd vdd p W='0.92*1u' L=lp_min
+ ad='areap(0.92,sdd)' as='areap(0.92,sdd)' pd='perip(0.92,sdd)'
+ ps='perip(0.92,sdd)'
MMMI_OAI21A._4 out net_1 MMI_OAI21A%net_1 gnd n W='0.92*1u' L=ln_min
+ ad='arean(0.92,sdd)' as='arean(0.92,sdd)' pd='perin(0.92,sdd)'
+ ps='perin(0.92,sdd)'
MMMI_OAI21A._5 MMI_OAI21A%net_1 in1 gnd gnd n W='0.92*1u' L=ln_min
+ ad='arean(0.92,sdd)' as='arean(0.92,sdd)' pd='perin(0.92,sdd)'
+ ps='perin(0.92,sdd)'
MMMI_OAI21A._6 MMI_OAI21A%net_1 in0 gnd gnd n W='0.92*1u' L=ln_min
+ ad='arean(0.92,sdd)' as='arean(0.92,sdd)' pd='perin(0.92,sdd)'
+ ps='perin(0.92,sdd)'
MMMI_OAI21A._7 out net_1 vdd vdd p W='0.92*1u' L=lp_min
+ ad='areap(0.92,sdd)' as='areap(0.92,sdd)' pd='perip(0.92,sdd)'
+ ps='perip(0.92,sdd)'
MMMI_OAI21A._8 out in1 MMI_OAI21A%net_2 vdd p W='1.84*1u' L=lp_min
+ ad='areap(1.84,sdd)' as='areap(1.84,sdd)' pd='perip(1.84,sdd)'
+ ps='perip(1.84,sdd)'
MMMI_OAI21A._9 MMI_OAI21A%net_2 in0 vdd vdd p W='1.84*1u' L=lp_min
+ ad='areap(1.84,sdd)' as='areap(1.84,sdd)' pd='perip(1.84,sdd)'
+ ps='perip(1.84,sdd)'
*.ENDS	$ MMI_XNOR2A
