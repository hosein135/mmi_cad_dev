* FILE: MMI_MUX2B.sp

* SPICE netlist for "MMI_MUX2B" (generated by MMI_SUE4.2.1)

*.SUBCKT MMI_MUX2B in0 in1 out sel
Minverter._0 out net_1 gnd gnd n W='0.92*1u' L=ln_min ad='arean(0.92,sdd)'
+ as='arean(0.92,sdd)' pd='perin(0.92,sdd)' ps='perin(0.92,sdd)'
Minverter._1 out net_1 vdd vdd p W='1.84*1u' L=lp_min ad='areap(1.84,sdd)'
+ as='areap(1.84,sdd)' pd='perip(1.84,sdd)' ps='perip(1.84,sdd)'
Mxgate._2 net_1 sel net_2 vdd p W='1.84*1u' L=lp_min ad='areap(1.84,sdd)'
+ as='areap(1.84,sdd)' pd='perip(1.84,sdd)' ps='perip(1.84,sdd)'
Mxgate._3 net_1 net_4 net_2 gnd n W='0.92*1u' L=ln_min ad='arean(0.92,sdd)'
+ as='arean(0.92,sdd)' pd='perin(0.92,sdd)' ps='perin(0.92,sdd)'
Minverter_1._4 net_2 in0 gnd gnd n W='0.92*1u' L=ln_min
+ ad='arean(0.92,sdd)' as='arean(0.92,sdd)' pd='perin(0.92,sdd)'
+ ps='perin(0.92,sdd)'
Minverter_1._5 net_2 in0 vdd vdd p W='1.84*1u' L=lp_min
+ ad='areap(1.84,sdd)' as='areap(1.84,sdd)' pd='perip(1.84,sdd)'
+ ps='perip(1.84,sdd)'
Mxgate_1._6 net_1 net_4 net_3 vdd p W='1.84*1u' L=lp_min
+ ad='areap(1.84,sdd)' as='areap(1.84,sdd)' pd='perip(1.84,sdd)'
+ ps='perip(1.84,sdd)'
Mxgate_1._7 net_1 sel net_3 gnd n W='0.92*1u' L=ln_min ad='arean(0.92,sdd)'
+ as='arean(0.92,sdd)' pd='perin(0.92,sdd)' ps='perin(0.92,sdd)'
Minverter_2._8 net_3 in1 gnd gnd n W='0.92*1u' L=ln_min
+ ad='arean(0.92,sdd)' as='arean(0.92,sdd)' pd='perin(0.92,sdd)'
+ ps='perin(0.92,sdd)'
Minverter_2._9 net_3 in1 vdd vdd p W='1.84*1u' L=lp_min
+ ad='areap(1.84,sdd)' as='areap(1.84,sdd)' pd='perip(1.84,sdd)'
+ ps='perip(1.84,sdd)'
Minverter_3._10 net_4 sel gnd gnd n W='0.46*1u' L=ln_min
+ ad='arean(0.46,sdd)' as='arean(0.46,sdd)' pd='perin(0.46,sdd)'
+ ps='perin(0.46,sdd)'
Minverter_3._11 net_4 sel vdd vdd p W='0.92*1u' L=lp_min
+ ad='areap(0.92,sdd)' as='areap(0.92,sdd)' pd='perip(0.92,sdd)'
+ ps='perip(0.92,sdd)'
*.ENDS	$ MMI_MUX2B
