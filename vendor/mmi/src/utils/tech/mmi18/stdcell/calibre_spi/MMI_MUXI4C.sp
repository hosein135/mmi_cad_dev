* FILE: MMI_MUXI4C.sp

* SPICE netlist for "MMI_MUXI4C" (generated by MMI_SUE4.2.1)

.SUBCKT MMI_MUXI4C in0 in1 in2 in3 out sel0 sel1
Mxgate._0 N2 sel1 N1 vdd p W='1.84*1u' L=lp_min
Mxgate._1 N2 sel1_L N1 gnd n W='0.92*1u' L=ln_min
Mxgate_1._2 N2 sel1_L N3 vdd p W='1.84*1u' L=lp_min
Mxgate_1._3 N2 sel1 N3 gnd n W='0.92*1u' L=ln_min
Minverter._4 sel1_L sel1 gnd gnd n W='0.46*1u' L=ln_min
Minverter._5 sel1_L sel1 vdd vdd p W='0.92*1u' L=lp_min
Mxgate_2._6 net_1 sel0 net_2 vdd p W='1.84*1u' L=lp_min
Mxgate_2._7 net_1 sel0_L net_2 gnd n W='0.92*1u' L=ln_min
Minverter_1._8 net_2 in0 gnd gnd n W='0.92*1u' L=ln_min
Minverter_1._9 net_2 in0 vdd vdd p W='1.84*1u' L=lp_min
Mxgate_3._10 net_1 sel0_L net_3 vdd p W='1.84*1u' L=lp_min
Mxgate_3._11 net_1 sel0 net_3 gnd n W='0.92*1u' L=ln_min
Minverter_2._12 net_3 in1 gnd gnd n W='0.92*1u' L=ln_min
Minverter_2._13 net_3 in1 vdd vdd p W='1.84*1u' L=lp_min
Minverter_3._14 N1 net_1 gnd gnd n W='0.92*1u' L=ln_min
Minverter_3._15 N1 net_1 vdd vdd p W='1.84*1u' L=lp_min
Mxgate_4._16 net_4 sel0 net_5 vdd p W='1.84*1u' L=lp_min
Mxgate_4._17 net_4 sel0_L net_5 gnd n W='0.92*1u' L=ln_min
Minverter_4._18 net_5 in2 gnd gnd n W='0.92*1u' L=ln_min
Minverter_4._19 net_5 in2 vdd vdd p W='1.84*1u' L=lp_min
Mxgate_5._20 net_4 sel0_L net_6 vdd p W='1.84*1u' L=lp_min
Mxgate_5._21 net_4 sel0 net_6 gnd n W='0.92*1u' L=ln_min
Minverter_5._22 net_6 in3 gnd gnd n W='0.92*1u' L=ln_min
Minverter_5._23 net_6 in3 vdd vdd p W='1.84*1u' L=lp_min
Minverter_6._24 N3 net_4 gnd gnd n W='0.92*1u' L=ln_min
Minverter_6._25 N3 net_4 vdd vdd p W='1.84*1u' L=lp_min
Minverter_7._26 sel0_L sel0 gnd gnd n W='0.92*1u' L=ln_min
Minverter_7._27 sel0_L sel0 vdd vdd p W='1.84*1u' L=lp_min
Minverter_8._28 out N2 gnd gnd n W='1.84*1u' L=ln_min
Minverter_8._29 out N2 vdd vdd p W='3.68*1u' L=lp_min
.ENDS	$ MMI_MUXI4C
