* FILE: MMI_INOR2B.sp

* SPICE netlist for "MMI_INOR2B" (generated by MMI_SUE4.2.1)

.SUBCKT MMI_INOR2B in0 in1 out
M_0 out in1_L gnd gnd n W='0.92*1u' L=ln_min
M_1_1 out in0 gnd gnd n W='0.92*1u' L=ln_min
M_2_1 out in1_L net_1 vdd p W='1.84*1u' L=lp_min
M_3_1 out in1_L net_2 vdd p W='1.84*1u' L=lp_min
M_4_1 net_2 in0 vdd vdd p W='1.84*1u' L=lp_min
M_5_1 net_1 in0 vdd vdd p W='1.84*1u' L=lp_min
Minverter._6 in1_L in1 gnd gnd n W='0.46*1u' L=ln_min
Minverter._7 in1_L in1 vdd vdd p W='0.92*1u' L=lp_min
.ENDS	$ MMI_INOR2B
