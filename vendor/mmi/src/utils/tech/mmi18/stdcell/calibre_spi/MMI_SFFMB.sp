* FILE: MMI_SFFMB.sp

* SPICE netlist for "MMI_SFFMB" (generated by MMI_SUE4.2.1)

.SUBCKT MMI_SFFMB clk d0 d1 q s_en s_in s_out sel
Minverter._0 q N5 gnd gnd n W='0.92*1u' L=ln_min
Minverter._1 q N5 vdd vdd p W='1.84*1u' L=lp_min
M_2_1 N1 d0 net_1 vdd p W='1.84*1u' L=lp_min
M_3_1 N1 d0 net_2 gnd n W='0.92*1u' L=ln_min
Minverter_1._4 clk_L clk gnd gnd n W='0.46*1u' L=ln_min
Minverter_1._5 clk_L clk vdd vdd p W='0.92*1u' L=lp_min
M_6_1 N1 s_en_L net_3 vdd p W='0.92*1u' L=lp_min
M_7_1 N1 s_en net_4 gnd n W='0.46*1u' L=ln_min
M_8_1 net_4 s_in gnd gnd n W='0.46*1u' L=ln_min
M_9_1 net_3 s_in vdd vdd p W='0.92*1u' L=lp_min
M_10_1 net_5 N5 gnd gnd n W='0.42*1u' L=ln_min
M_11_1 N4 clk net_6 vdd p W='0.42*1u' L=lp_min
M_12_1 N4 clk_L net_5 gnd n W='0.42*1u' L=ln_min
M_13_1 net_6 N5 vdd vdd p W='0.42*1u' L=lp_min
M_14_1 net_7 N3 vdd vdd p W='0.42*1u' L=lp_min
M_15_1 N2 clk_L net_7 vdd p W='0.42*1u' L=lp_min
M_16_1 N2 clk net_8 gnd n W='0.42*1u' L=ln_min
M_17_1 net_8 N3 gnd gnd n W='0.42*1u' L=ln_min
Mxgate._18 N4 clk_L N3 vdd p W='0.92*1u' L=lp_min
Mxgate._19 N4 clk N3 gnd n W='0.42*1u' L=ln_min
Mxgate_1._20 N1 clk N2 vdd p W='0.92*1u' L=lp_min
Mxgate_1._21 N1 clk_L N2 gnd n W='0.42*1u' L=ln_min
Mnand2._22 s_out N5 vdd vdd p W='0.84*1u' L=lp_min
Mnand2._23 s_out N5 nand2%net_1 gnd n W='0.84*1u' L=ln_min
Mnand2._24 s_out s_en vdd vdd p W='0.84*1u' L=lp_min
Mnand2._25 nand2%net_1 s_en gnd gnd n W='0.84*1u' L=ln_min
Minverter_2._26 N5 N4 gnd gnd n W='0.62*1u' L=ln_min
Minverter_2._27 N5 N4 vdd vdd p W='0.92*1u' L=lp_min
Minverter_3._28 N3 N2 gnd gnd n W='0.46*1u' L=ln_min
Minverter_3._29 N3 N2 vdd vdd p W='0.92*1u' L=lp_min
M_30_1 net_1 sel net_9 vdd p W='1.84*1u' L=lp_min
M_31_1 N1 d1 net_10 vdd p W='1.84*1u' L=lp_min
M_32_1 net_10 sel_L net_9 vdd p W='1.84*1u' L=lp_min
M_33_1 net_2 sel_L net_11 gnd n W='0.92*1u' L=ln_min
M_34_1 net_12 sel net_11 gnd n W='0.92*1u' L=ln_min
M_35_1 N1 d1 net_12 gnd n W='0.92*1u' L=ln_min
M_36_1 net_9 s_en vdd vdd p W='3.68*1u' L=lp_min
M_37_1 net_11 s_en_L gnd gnd n W='1.84*1u' L=ln_min
Minverter_4._38 s_en_L s_en gnd gnd n W='0.46*1u' L=ln_min
Minverter_4._39 s_en_L s_en vdd vdd p W='0.92*1u' L=lp_min
Minverter_5._40 sel_L sel gnd gnd n W='0.46*1u' L=ln_min
Minverter_5._41 sel_L sel vdd vdd p W='0.92*1u' L=lp_min
.ic N4=0V
.ENDS	$ MMI_SFFMB
