* FILE: MMI_MUXI2A.sp

* SPICE netlist for "MMI_MUXI2A" (generated by MMI_SUE4.2.1)

.SUBCKT MMI_MUXI2A in0 in1 out sel
Minverter._0 net_1 sel gnd gnd n W='0.46*1u' L=ln_min
Minverter._1 net_1 sel vdd vdd p W='0.92*1u' L=lp_min
Mxgate._2 out sel net_2 vdd p W='1.84*1u' L=lp_min
Mxgate._3 out net_1 net_2 gnd n W='0.92*1u' L=ln_min
Minverter_1._4 net_2 in0 gnd gnd n W='0.92*1u' L=ln_min
Minverter_1._5 net_2 in0 vdd vdd p W='1.84*1u' L=lp_min
Minverter_2._6 net_3 in1 gnd gnd n W='0.92*1u' L=ln_min
Minverter_2._7 net_3 in1 vdd vdd p W='1.84*1u' L=lp_min
Mxgate_1._8 out net_1 net_3 vdd p W='1.84*1u' L=lp_min
Mxgate_1._9 out sel net_3 gnd n W='0.92*1u' L=ln_min
.ENDS	$ MMI_MUXI2A
