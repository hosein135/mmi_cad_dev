* FILE: MMI_OA21C.sp

* SPICE netlist for "MMI_OA21C" (generated by MMI_SUE4.2.1)

.SUBCKT MMI_OA21C in0 in1 in2 out
Minverter1._0 out N1 gnd gnd n W='1.84*1u' L=ln_min
Minverter1._1 out N1 vdd vdd p W='3.68*1u' L=lp_min
M_2_1 N1 in0 net_1 gnd n W='1.24*1u' L=ln_min
M_3_1 net_1 in1 gnd gnd n W='1.24*1u' L=ln_min
M_4_1 net_1 in2 gnd gnd n W='1.24*1u' L=ln_min
M_5_1 N1 in0 vdd vdd p W='1.24*1u' L=lp_min
M_6_1 N1 in1 net_2 vdd p W='2.48*1u' L=lp_min
M_7_1 net_2 in2 vdd vdd p W='2.48*1u' L=lp_min
.ENDS	$ MMI_OA21C
