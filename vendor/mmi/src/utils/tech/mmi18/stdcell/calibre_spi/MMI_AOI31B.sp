* FILE: MMI_AOI31B.sp

* SPICE netlist for "MMI_AOI31B" (generated by MMI_SUE4.2.1)

.SUBCKT MMI_AOI31B in0 in1 in2 in3 out
M_0 out in0 gnd gnd n W='0.92*1u' L=ln_min
M_1_1 out in1 net_1 gnd n W='1.38*1u' L=ln_min
M_2_1 out in1 net_2 gnd n W='1.38*1u' L=ln_min
M_3_1 net_2 in2 net_3 gnd n W='1.38*1u' L=ln_min
M_4_1 net_1 in2 net_4 gnd n W='1.38*1u' L=ln_min
M_5_1 net_4 in3 gnd gnd n W='1.38*1u' L=ln_min
M_6_1 net_3 in3 gnd gnd n W='1.38*1u' L=ln_min
M_7_1 out in0 net_5 vdd p W='1.84*1u' L=lp_min
M_8_1 out in0 net_5 vdd p W='1.84*1u' L=lp_min
M_9_1 net_5 in1 vdd vdd p W='1.84*1u' L=lp_min
M_10_1 net_5 in1 vdd vdd p W='1.84*1u' L=lp_min
M_11_1 net_5 in2 vdd vdd p W='1.84*1u' L=lp_min
M_12_1 net_5 in2 vdd vdd p W='1.84*1u' L=lp_min
M_13_1 net_5 in3 vdd vdd p W='1.84*1u' L=lp_min
M_14_1 net_5 in3 vdd vdd p W='1.84*1u' L=lp_min
.ENDS	$ MMI_AOI31B
