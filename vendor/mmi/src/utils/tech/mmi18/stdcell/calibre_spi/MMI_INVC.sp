* FILE: MMI_INVC.sp

* SPICE netlist for "MMI_INVC" (generated by MMI_SUE4.2.1)

.SUBCKT MMI_INVC in out
M_0 out in gnd gnd n W='1.84*1u' L=ln_min
M_1_1 out in vdd vdd p W='3.68*1u' L=lp_min
.ENDS	$ MMI_INVC
