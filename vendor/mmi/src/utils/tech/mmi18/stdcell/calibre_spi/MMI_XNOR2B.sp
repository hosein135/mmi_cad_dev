* FILE: MMI_XNOR2B.sp

* SPICE netlist for "MMI_XNOR2B" (generated by MMI_SUE4.2.1)

.SUBCKT MMI_XNOR2B in0 in1 out
MMMI_NAND2A._0 MMI_NAND2A%net_1 in1 gnd gnd n W='0.92*1u' L=ln_min
MMMI_NAND2A._1 net_1 in0 MMI_NAND2A%net_1 gnd n W='0.92*1u' L=ln_min
MMMI_NAND2A._2 net_1 in1 vdd vdd p W='0.92*1u' L=lp_min
MMMI_NAND2A._3 net_1 in0 vdd vdd p W='0.92*1u' L=lp_min
MMMI_OAI21B._4 out net_1 MMI_OAI21B%net_1 gnd n W='1.84*1u' L=ln_min
MMMI_OAI21B._5 MMI_OAI21B%net_1 in1 gnd gnd n W='1.84*1u' L=ln_min
MMMI_OAI21B._6 MMI_OAI21B%net_1 in0 gnd gnd n W='1.84*1u' L=ln_min
MMMI_OAI21B._7 out net_1 vdd vdd p W='1.84*1u' L=lp_min
MMMI_OAI21B._8 out in1 MMI_OAI21B%net_2 vdd p W='1.84*1u' L=lp_min
MMMI_OAI21B._9 out in1 MMI_OAI21B%net_3 vdd p W='1.84*1u' L=lp_min
MMMI_OAI21B._10 MMI_OAI21B%net_2 in0 vdd vdd p W='1.84*1u' L=lp_min
MMMI_OAI21B._11 MMI_OAI21B%net_3 in0 vdd vdd p W='1.84*1u' L=lp_min
.ENDS	$ MMI_XNOR2B
