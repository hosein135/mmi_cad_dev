* FILE: MMI_MUXI2B.sp

* SPICE netlist for "MMI_MUXI2B" (generated by MMI_SUE4.2.1)

.SUBCKT MMI_MUXI2B in0 in1 out sel
Mxgate._0 out sel net_1 vdd p W='3.68*1u' L=lp_min
Mxgate._1 out net_3 net_1 gnd n W='1.84*1u' L=ln_min
Minverter._2 net_1 in0 gnd gnd n W='1.84*1u' L=ln_min
Minverter._3 net_1 in0 vdd vdd p W='3.68*1u' L=lp_min
Minverter_1._4 net_2 in1 gnd gnd n W='1.84*1u' L=ln_min
Minverter_1._5 net_2 in1 vdd vdd p W='3.68*1u' L=lp_min
Mxgate_1._6 out net_3 net_2 vdd p W='3.68*1u' L=lp_min
Mxgate_1._7 out sel net_2 gnd n W='1.84*1u' L=ln_min
Minverter_2._8 net_3 sel gnd gnd n W='0.62*1u' L=ln_min
Minverter_2._9 net_3 sel vdd vdd p W='1.24*1u' L=lp_min
.ENDS	$ MMI_MUXI2B
