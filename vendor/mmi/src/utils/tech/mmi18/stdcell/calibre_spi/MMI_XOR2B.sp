* FILE: MMI_XOR2B.sp

* SPICE netlist for "MMI_XOR2B" (generated by MMI_SUE4.2.1)

.SUBCKT MMI_XOR2B in0 in1 out
MMMI_NOR2A._0 net_1 in0 gnd gnd n W='0.46*1u' L=ln_min
MMMI_NOR2A._1 net_1 in1 gnd gnd n W='0.46*1u' L=ln_min
MMMI_NOR2A._2 net_1 in0 MMI_NOR2A%net_1 vdd p W='1.84*1u' L=lp_min
MMMI_NOR2A._3 MMI_NOR2A%net_1 in1 vdd vdd p W='1.84*1u' L=lp_min
MMMI_AOI21B._4 out net_1 gnd gnd n W='0.92*1u' L=ln_min
MMMI_AOI21B._5 out in1 MMI_AOI21B%net_1 gnd n W='1.84*1u' L=ln_min
MMMI_AOI21B._6 MMI_AOI21B%net_1 in0 gnd gnd n W='1.84*1u' L=ln_min
MMMI_AOI21B._7 out net_1 MMI_AOI21B%net_2 vdd p W='3.68*1u' L=lp_min
MMMI_AOI21B._8 MMI_AOI21B%net_2 in0 vdd vdd p W='3.68*1u' L=lp_min
MMMI_AOI21B._9 MMI_AOI21B%net_2 in1 vdd vdd p W='3.68*1u' L=lp_min
.ENDS	$ MMI_XOR2B
