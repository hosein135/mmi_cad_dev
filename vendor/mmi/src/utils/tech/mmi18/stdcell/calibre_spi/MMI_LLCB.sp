* FILE: MMI_LLCB.sp

* SPICE netlist for "MMI_LLCB" (generated by MMI_SUE4.2.1)

.SUBCKT MMI_LLCB clk clrb d q
Minverter._0 N1 d gnd gnd n W='0.92*1u' L=ln_min
Minverter._1 N1 d vdd vdd p W='1.84*1u' L=lp_min
M_2_1 net_1 N5 gnd gnd n W='0.42*1u' L=ln_min
M_3_1 N2 clk_L net_2 vdd p W='0.42*1u' L=lp_min
M_4_1 net_2 N5 vdd vdd p W='0.42*1u' L=lp_min
M_5_1 N2 clk net_1 gnd n W='0.42*1u' L=ln_min
Minverter_1._6 clk_L clk gnd gnd n W='0.46*1u' L=ln_min
Minverter_1._7 clk_L clk vdd vdd p W='0.92*1u' L=lp_min
Mxgate._8 N2 clk N1 vdd p W='1.84*1u' L=lp_min
Mxgate._9 N2 clk_L N1 gnd n W='0.92*1u' L=ln_min
Minverter_2._10 q net_3 gnd gnd n W='0.92*1u' L=ln_min
Minverter_2._11 q net_3 vdd vdd p W='1.84*1u' L=lp_min
Minverter_3._12 net_3 N5 gnd gnd n W='0.46*1u' L=ln_min
Minverter_3._13 net_3 N5 vdd vdd p W='0.92*1u' L=lp_min
Mnor2._14 N5 N2 gnd gnd n W='0.46*1u' L=ln_min
Mnor2._15 N5 N2 nor2%net_1 vdd p W='1.84*1u' L=lp_min
Mnor2._16 N5 net_4 gnd gnd n W='0.46*1u' L=ln_min
Mnor2._17 nor2%net_1 net_4 vdd vdd p W='1.84*1u' L=lp_min
Minverter_4._18 net_4 clrb gnd gnd n W='0.46*1u' L=ln_min
Minverter_4._19 net_4 clrb vdd vdd p W='0.92*1u' L=lp_min
.ENDS	$ MMI_LLCB
