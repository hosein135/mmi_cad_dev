* FILE: MMI_NAND2D.sp

* SPICE netlist for "MMI_NAND2D" (generated by MMI_SUE4.2.1)

.SUBCKT MMI_NAND2D in0 in1 out
M_0 out in0 vdd vdd p W='3.68*1u' L=lp_min
M_1_1 out in0 vdd vdd p W='3.68*1u' L=lp_min
M_2_1 out in1 vdd vdd p W='3.68*1u' L=lp_min
M_3_1 out in1 vdd vdd p W='3.68*1u' L=lp_min
M_4_1 out in0 net_1 gnd n W='1.84*1u' L=ln_min
M_5_1 out in0 net_2 gnd n W='1.84*1u' L=ln_min
M_6_1 net_1 in1 gnd gnd n W='1.84*1u' L=ln_min
M_7_1 net_2 in1 gnd gnd n W='1.84*1u' L=ln_min
M_8_1 out in0 net_3 gnd n W='1.84*1u' L=ln_min
M_9_1 out in0 net_4 gnd n W='1.84*1u' L=ln_min
M_10_1 net_3 in1 gnd gnd n W='1.84*1u' L=ln_min
M_11_1 net_4 in1 gnd gnd n W='1.84*1u' L=ln_min
.ENDS	$ MMI_NAND2D
