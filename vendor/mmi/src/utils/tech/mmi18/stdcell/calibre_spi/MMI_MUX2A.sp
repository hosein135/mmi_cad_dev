* FILE: MMI_MUX2A.sp

* SPICE netlist for "MMI_MUX2A" (generated by MMI_SUE4.2.1)

.SUBCKT MMI_MUX2A in0 in1 out sel
Mxgate._0 net_1 net_3 net_2 vdd p W='1.84*1u' L=lp_min
Mxgate._1 net_1 sel net_2 gnd n W='0.92*1u' L=ln_min
Minverter._2 net_3 sel gnd gnd n W='0.46*1u' L=ln_min
Minverter._3 net_3 sel vdd vdd p W='0.92*1u' L=lp_min
Minverter_1._4 out net_1 gnd gnd n W='0.46*1u' L=ln_min
Minverter_1._5 out net_1 vdd vdd p W='0.92*1u' L=lp_min
Minverter_2._6 net_2 in1 gnd gnd n W='0.46*1u' L=ln_min
Minverter_2._7 net_2 in1 vdd vdd p W='0.92*1u' L=lp_min
Minverter_3._8 net_4 in0 gnd gnd n W='0.46*1u' L=ln_min
Minverter_3._9 net_4 in0 vdd vdd p W='0.92*1u' L=lp_min
Mxgate_1._10 net_1 sel net_4 vdd p W='0.92*1u' L=lp_min
Mxgate_1._11 net_1 net_3 net_4 gnd n W='0.46*1u' L=ln_min
.ENDS	$ MMI_MUX2A
