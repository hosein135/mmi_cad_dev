* FILE: MMI_MUX2B.sp

* SPICE netlist for "MMI_MUX2B" (generated by MMI_SUE4.2.1)

.SUBCKT MMI_MUX2B in0 in1 out sel
Minverter._0 out net_1 gnd gnd n W='0.92*1u' L=ln_min
Minverter._1 out net_1 vdd vdd p W='1.84*1u' L=lp_min
Mxgate._2 net_1 sel net_2 vdd p W='1.84*1u' L=lp_min
Mxgate._3 net_1 net_4 net_2 gnd n W='0.92*1u' L=ln_min
Minverter_1._4 net_2 in0 gnd gnd n W='0.92*1u' L=ln_min
Minverter_1._5 net_2 in0 vdd vdd p W='1.84*1u' L=lp_min
Mxgate_1._6 net_1 net_4 net_3 vdd p W='1.84*1u' L=lp_min
Mxgate_1._7 net_1 sel net_3 gnd n W='0.92*1u' L=ln_min
Minverter_2._8 net_3 in1 gnd gnd n W='0.92*1u' L=ln_min
Minverter_2._9 net_3 in1 vdd vdd p W='1.84*1u' L=lp_min
Minverter_3._10 net_4 sel gnd gnd n W='0.46*1u' L=ln_min
Minverter_3._11 net_4 sel vdd vdd p W='0.92*1u' L=lp_min
.ENDS	$ MMI_MUX2B
