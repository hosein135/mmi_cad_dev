* FILE: MMI_LTCHPB.sp

* SPICE netlist for "MMI_LTCHPB" (generated by MMI_SUE4.2.1)

.SUBCKT MMI_LTCHPB clk d q
Mxgate._0 N2 clk_L N1 vdd p W='1.84*1u' L=lp_min
Mxgate._1 N2 clk N1 gnd n W='0.92*1u' L=ln_min
Minverter._2 N1 d gnd gnd n W='0.92*1u' L=ln_min
Minverter._3 N1 d vdd vdd p W='1.84*1u' L=lp_min
M_4_1 net_1 N5 gnd gnd n W='0.42*1u' L=ln_min
M_5_1 N2 clk net_2 vdd p W='0.42*1u' L=lp_min
M_6_1 net_2 N5 vdd vdd p W='0.42*1u' L=lp_min
M_7_1 N2 clk_L net_1 gnd n W='0.42*1u' L=ln_min
Minverter_1._8 clk_L clk gnd gnd n W='0.46*1u' L=ln_min
Minverter_1._9 clk_L clk vdd vdd p W='0.92*1u' L=lp_min
Minverter_2._10 q N2 gnd gnd n W='0.92*1u' L=ln_min
Minverter_2._11 q N2 vdd vdd p W='1.84*1u' L=lp_min
Minverter_3._12 N5 N2 gnd gnd n W='0.46*1u' L=ln_min
Minverter_3._13 N5 N2 vdd vdd p W='0.92*1u' L=lp_min
.ENDS	$ MMI_LTCHPB
