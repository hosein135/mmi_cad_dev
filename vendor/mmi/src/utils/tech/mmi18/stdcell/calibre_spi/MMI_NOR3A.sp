* FILE: MMI_NOR3A.sp

* SPICE netlist for "MMI_NOR3A" (generated by MMI_SUE4.2.1)

.SUBCKT MMI_NOR3A in0 in1 in2 out
M_0 out in0 gnd gnd n W='0.46*1u' L=ln_min
M_1_1 out in1 gnd gnd n W='0.46*1u' L=ln_min
M_2_1 out in2 gnd gnd n W='0.46*1u' L=ln_min
M_3_1 out in0 net_1 vdd p W='2.76*1u' L=lp_min
M_4_1 net_1 in1 net_2 vdd p W='2.76*1u' L=lp_min
M_5_1 net_2 in2 vdd vdd p W='2.76*1u' L=lp_min
.ENDS	$ MMI_NOR3A
