* FILE: MMI_LTCHNB.sp

* SPICE netlist for "MMI_LTCHNB" (generated by MMI_SUE4.2.1)

.SUBCKT MMI_LTCHNB clk d q
Minverter._0 N1 d gnd gnd n W='0.92*1u' L=ln_min
Minverter._1 N1 d vdd vdd p W='1.84*1u' L=lp_min
M_2_1 net_1 N5 gnd gnd n W='0.42*1u' L=ln_min
M_3_1 N2 clk_L net_2 vdd p W='0.42*1u' L=lp_min
M_4_1 net_2 N5 vdd vdd p W='0.42*1u' L=lp_min
M_5_1 N2 clk net_1 gnd n W='0.42*1u' L=ln_min
Minverter_1._6 clk_L clk gnd gnd n W='0.46*1u' L=ln_min
Minverter_1._7 clk_L clk vdd vdd p W='0.92*1u' L=lp_min
Minverter_2._8 q N2 gnd gnd n W='0.92*1u' L=ln_min
Minverter_2._9 q N2 vdd vdd p W='1.84*1u' L=lp_min
Minverter_3._10 N5 N2 gnd gnd n W='0.46*1u' L=ln_min
Minverter_3._11 N5 N2 vdd vdd p W='0.92*1u' L=lp_min
Mxgate._12 N2 clk N1 vdd p W='1.84*1u' L=lp_min
Mxgate._13 N2 clk_L N1 gnd n W='0.92*1u' L=ln_min
.ENDS	$ MMI_LTCHNB
