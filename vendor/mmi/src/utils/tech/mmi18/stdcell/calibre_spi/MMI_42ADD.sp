* FILE: MMI_42ADD.sp

* SPICE netlist for "MMI_42ADD" (generated by MMI_SUE4.2.1)

.SUBCKT MMI_42ADD Carry_H Cin_L Cout_L In1_H In2_H In3_H In4_H Sum_H
M_0 net_1 odd_inputs Cin_L gnd n W='0.8*1u' L=ln_min
M_1_1 net_1 even_inputs net_2 gnd n W='0.8*1u' L=ln_min
M_2_1 net_3 odd_inputs net_2 gnd n W='0.8*1u' L=ln_min
M_3_1 net_3 even_inputs net_4 gnd n W='0.8*1u' L=ln_min
M_4_1 even_inputs In1_XOR_In2 In3_XNOR_In4 vdd p W='1.6*1u' L=lp_min
M_5_1 even_inputs In1_XNOR_In2 In3_XOR_In4 vdd p W='1.6*1u' L=lp_min
M_6_1 odd_inputs In1_XOR_In2 In3_XOR_In4 vdd p W='1.6*1u' L=lp_min
M_7_1 odd_inputs In1_XNOR_In2 In3_XNOR_In4 vdd p W='1.6*1u' L=lp_min
M_8_1 In3_XNOR_In4 In3_H net_5 vdd p W='3.2*1u' L=lp_min
M_9_1 In3_XNOR_In4 net_6 net_5 gnd n W='1.6*1u' L=ln_min
M_10_1 In3_XNOR_In4 In3_H In4_H gnd n W='1.6*1u' L=ln_min
M_11_1 In3_XOR_In4 net_6 In4_H gnd n W='1.6*1u' L=ln_min
M_12_1 In3_XOR_In4 In3_H net_5 gnd n W='1.6*1u' L=ln_min
M_13_1 In3_XNOR_In4 net_6 In4_H vdd p W='3.2*1u' L=lp_min
M_14_1 In3_XOR_In4 In3_H In4_H vdd p W='3.2*1u' L=lp_min
M_15_1 In3_XOR_In4 net_6 net_5 vdd p W='3.2*1u' L=lp_min
Maoi22._16 Cout_L In4_H aoi22%net_1 gnd n W='2.76*1u' L=ln_min
Maoi22._17 Cout_L In4_H aoi22%net_2 vdd p W='4.56*1u' L=lp_min
Maoi22._18 aoi22%net_1 In3_H gnd gnd n W='2.76*1u' L=ln_min
Maoi22._19 Cout_L In3_H aoi22%net_2 vdd p W='4.56*1u' L=lp_min
Maoi22._20 Cout_L In2_H aoi22%net_3 gnd n W='2.76*1u' L=ln_min
Maoi22._21 aoi22%net_2 In2_H vdd vdd p W='4.56*1u' L=lp_min
Maoi22._22 aoi22%net_3 In1_H gnd gnd n W='2.76*1u' L=ln_min
Maoi22._23 aoi22%net_2 In1_H vdd vdd p W='4.56*1u' L=lp_min
Minverter._24 net_6 In3_H gnd gnd n W='1.2*1u' L=ln_min
Minverter._25 net_6 In3_H vdd vdd p W='2.4*1u' L=lp_min
Minverter_1._26 net_7 In1_H gnd gnd n W='0.8*1u' L=ln_min
Minverter_1._27 net_7 In1_H vdd vdd p W='1.6*1u' L=lp_min
M_28_1 In1_XNOR_In2 In1_H net_8 vdd p W='1.6*1u' L=lp_min
M_29_1 In1_XNOR_In2 net_7 net_8 gnd n W='0.8*1u' L=ln_min
M_30_1 In1_XNOR_In2 In1_H In2_H gnd n W='0.8*1u' L=ln_min
M_31_1 In1_XOR_In2 net_7 In2_H gnd n W='0.8*1u' L=ln_min
M_32_1 In1_XOR_In2 In1_H net_8 gnd n W='0.8*1u' L=ln_min
M_33_1 In1_XNOR_In2 net_7 In2_H vdd p W='1.6*1u' L=lp_min
M_34_1 In1_XOR_In2 In1_H In2_H vdd p W='1.6*1u' L=lp_min
M_35_1 In1_XOR_In2 net_7 net_8 vdd p W='1.6*1u' L=lp_min
Minverter_2._36 net_5 In4_H gnd gnd n W='2.2*1u' L=ln_min
Minverter_2._37 net_5 In4_H vdd vdd p W='4.4*1u' L=lp_min
M_38_1 even_inputs In1_XNOR_In2 In3_XNOR_In4 gnd n W='0.8*1u' L=ln_min
M_39_1 even_inputs In1_XOR_In2 In3_XOR_In4 gnd n W='0.8*1u' L=ln_min
M_40_1 odd_inputs In1_XNOR_In2 In3_XOR_In4 gnd n W='0.8*1u' L=ln_min
M_41_1 odd_inputs In1_XOR_In2 In3_XNOR_In4 gnd n W='0.8*1u' L=ln_min
Minverter_3._42 net_9 net_1 gnd gnd n W='1.24*1u' L=ln_min
Minverter_3._43 net_9 net_1 vdd vdd p W='1.86*1u' L=lp_min
M_44_1 net_3 odd_inputs net_4 vdd p W='1.6*1u' L=lp_min
M_45_1 net_3 even_inputs net_2 vdd p W='1.6*1u' L=lp_min
M_46_1 net_1 odd_inputs net_2 vdd p W='1.6*1u' L=lp_min
M_47_1 net_1 even_inputs Cin_L vdd p W='1.6*1u' L=lp_min
Minverter_4._48 net_10 net_3 gnd gnd n W='1.24*1u' L=ln_min
Minverter_4._49 net_10 net_3 vdd vdd p W='2.48*1u' L=lp_min
Minverter_5._50 net_8 In2_H gnd gnd n W='0.8*1u' L=ln_min
Minverter_5._51 net_8 In2_H vdd vdd p W='1.6*1u' L=lp_min
Minverter1._52 net_4 net_11 gnd gnd n W='2.2*1u' L=ln_min
Minverter1._53 net_4 net_11 vdd vdd p W='4.4*1u' L=lp_min
Minverter1_1._54 net_2 Cin_L gnd gnd n W='3.2*1u' L=ln_min
Minverter1_1._55 net_2 Cin_L vdd vdd p W='3.2*1u' L=lp_min
Moai2_2._56 net_11 In1_H oai2_2%net_1 vdd p W='3.68*1u' L=lp_min
Moai2_2._57 net_11 In1_H oai2_2%net_2 gnd n W='1.84*1u' L=ln_min
Moai2_2._58 oai2_2%net_1 In2_H vdd vdd p W='3.68*1u' L=lp_min
Moai2_2._59 net_11 In2_H oai2_2%net_2 gnd n W='1.84*1u' L=ln_min
Moai2_2._60 net_11 In3_H oai2_2%net_3 vdd p W='3.68*1u' L=lp_min
Moai2_2._61 oai2_2%net_2 In3_H gnd gnd n W='1.84*1u' L=ln_min
Moai2_2._62 oai2_2%net_3 In4_H vdd vdd p W='3.68*1u' L=lp_min
Moai2_2._63 oai2_2%net_2 In4_H gnd gnd n W='1.84*1u' L=ln_min
Minverter1_2._64 Carry_H net_10 gnd gnd n W='3.68*1u' L=ln_min
Minverter1_2._65 Carry_H net_10 vdd vdd p W='7.36*1u' L=lp_min
Minverter1_3._66 Sum_H net_9 gnd gnd n W='3.68*1u' L=ln_min
Minverter1_3._67 Sum_H net_9 vdd vdd p W='7.36*1u' L=lp_min
.ENDS	$ MMI_42ADD
