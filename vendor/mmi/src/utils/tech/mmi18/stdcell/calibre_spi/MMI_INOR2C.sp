* FILE: MMI_INOR2C.sp

* SPICE netlist for "MMI_INOR2C" (generated by MMI_SUE4.2.1)

.SUBCKT MMI_INOR2C in0 in1 out
M_0 out in1_L gnd gnd n W='1.84*1u' L=ln_min
M_1_1 out in0 gnd gnd n W='1.84*1u' L=ln_min
M_2_1 out in1_L net_1 vdd p W='1.84*1u' L=lp_min
M_3_1 out in1_L net_2 vdd p W='1.84*1u' L=lp_min
M_4_1 out in1_L net_3 vdd p W='1.84*1u' L=lp_min
M_5_1 out in1_L net_4 vdd p W='1.84*1u' L=lp_min
M_6_1 net_4 in0 vdd vdd p W='1.84*1u' L=lp_min
M_7_1 net_3 in0 vdd vdd p W='1.84*1u' L=lp_min
M_8_1 net_2 in0 vdd vdd p W='1.84*1u' L=lp_min
M_9_1 net_1 in0 vdd vdd p W='1.84*1u' L=lp_min
Minverter._10 in1_L in1 gnd gnd n W='0.92*1u' L=ln_min
Minverter._11 in1_L in1 vdd vdd p W='1.84*1u' L=lp_min
.ENDS	$ MMI_INOR2C
