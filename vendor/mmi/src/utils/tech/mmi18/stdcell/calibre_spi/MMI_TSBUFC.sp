* FILE: MMI_TSBUFC.sp

* SPICE netlist for "MMI_TSBUFC" (generated by MMI_SUE4.2.1)

.SUBCKT MMI_TSBUFC en enb in out
M_0 out N2 vdd vdd p W='3.68*1u' L=lp_min
M_1_1 out N1 gnd gnd n W='1.84*1u' L=ln_min
M_2_1 N2 en vdd vdd p W='0.84*1u' L=lp_min
M_3_1 N1 enb N2 vdd p W='0.84*1u' L=lp_min
M_4_1 N2 en N1 gnd n W='0.42*1u' L=ln_min
M_5_1 N1 enb gnd gnd n W='0.42*1u' L=ln_min
M_6_1 N2 in vdd vdd p W='1.68*1u' L=lp_min
M_7_1 N1 in gnd gnd n W='0.84*1u' L=ln_min
.ENDS	$ MMI_TSBUFC
