* FILE: MMI_CLKBUFB.sp

* SPICE netlist for "MMI_CLKBUFB" (generated by MMI_SUE4.1.5)

.SUBCKT inverter in out WP=2 LP=lp_min WN=1 LN=ln_min
M_0 out in gnd gnd n W='WN*1u' L=LN
M_1 out in vdd vdd p W='WP*1u' L=LP
.ENDS	$ inverter

.SUBCKT inverter1 in out WP=2 LP=lp_min WN=1 LN=ln_min
M_0 out in gnd gnd n W='WN*1u' L=LN
M_1 out in vdd vdd p W='WP*1u' L=LP
.ENDS	$ inverter1

.SUBCKT MMI_CLKBUFB clk g_clk g_scan_en scan_en scan_in scan_out
Xinverter clk unused inverter WP=4.8 WN=2.4
Xinverter_1 g_clk g_clk_L inverter WP=1.2 WN=0.6
Xinverter1 g_clk_L clk inverter1 WP=2.4 WN=1.2
Xinverter_2 g_scan_en g_scan_en_L inverter WP=1.2 WN=0.6
Xinverter1_1 g_scan_en_L scan_en inverter1 WP=2.4 WN=1.2
Xinverter_3 scan_in scan_in_L inverter WP=1.6 WN=0.8
Xinverter1_2 scan_in_L scan_out inverter1 WP=4.8 WN=2.4
.ENDS	$ MMI_CLKBUFB

.GLOBAL gnd vdd
