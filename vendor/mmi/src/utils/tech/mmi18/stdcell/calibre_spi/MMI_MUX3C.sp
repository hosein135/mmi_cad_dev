* FILE: MMI_MUX3C.sp

* SPICE netlist for "MMI_MUX3C" (generated by MMI_SUE4.2.1)

.SUBCKT MMI_MUX3C in0 in1 in2 out sel0 sel1
Mxgate._0 N2 sel1 N1 vdd p W='1.84*1u' L=lp_min
Mxgate._1 N2 sel1_L N1 gnd n W='0.92*1u' L=ln_min
Mxgate_1._2 N2 sel1_L in2_L vdd p W='1.84*1u' L=lp_min
Mxgate_1._3 N2 sel1 in2_L gnd n W='0.92*1u' L=ln_min
Minverter._4 in2_L in2 gnd gnd n W='0.92*1u' L=ln_min
Minverter._5 in2_L in2 vdd vdd p W='1.84*1u' L=lp_min
Minverter_1._6 sel1_L sel1 gnd gnd n W='0.46*1u' L=ln_min
Minverter_1._7 sel1_L sel1 vdd vdd p W='0.92*1u' L=lp_min
Mxgate_2._8 N1 sel0 net_1 vdd p W='1.84*1u' L=lp_min
Mxgate_2._9 N1 net_3 net_1 gnd n W='0.92*1u' L=ln_min
Minverter_2._10 net_1 in0 gnd gnd n W='0.92*1u' L=ln_min
Minverter_2._11 net_1 in0 vdd vdd p W='1.84*1u' L=lp_min
Mxgate_3._12 N1 net_3 net_2 vdd p W='1.84*1u' L=lp_min
Mxgate_3._13 N1 sel0 net_2 gnd n W='0.92*1u' L=ln_min
Minverter_3._14 net_2 in1 gnd gnd n W='0.92*1u' L=ln_min
Minverter_3._15 net_2 in1 vdd vdd p W='1.84*1u' L=lp_min
Minverter_4._16 net_3 sel0 gnd gnd n W='0.46*1u' L=ln_min
Minverter_4._17 net_3 sel0 vdd vdd p W='0.92*1u' L=lp_min
Minverter_5._18 out N2 gnd gnd n W='1.84*1u' L=ln_min
Minverter_5._19 out N2 vdd vdd p W='3.68*1u' L=lp_min
.ENDS	$ MMI_MUX3C
