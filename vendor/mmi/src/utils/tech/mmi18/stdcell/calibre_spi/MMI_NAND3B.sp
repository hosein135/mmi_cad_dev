* FILE: MMI_NAND3B.sp

* SPICE netlist for "MMI_NAND3B" (generated by MMI_SUE4.2.1)

.SUBCKT MMI_NAND3B in0 in1 in2 out
M_0 out in0 vdd vdd p W='1.84*1u' L=lp_min
M_1_1 out in1 vdd vdd p W='1.84*1u' L=lp_min
M_2_1 out in2 vdd vdd p W='1.84*1u' L=lp_min
M_3_1 out in0 net_1 gnd n W='2.76*1u' L=ln_min
M_4_1 net_1 in1 net_2 gnd n W='2.76*1u' L=ln_min
M_5_1 net_2 in2 gnd gnd n W='2.76*1u' L=ln_min
.ENDS	$ MMI_NAND3B
