* FILE: MMI_NOR2A.sp

* SPICE netlist for "MMI_NOR2A" (generated by MMI_SUE4.2.1)

.SUBCKT MMI_NOR2A in0 in1 out
M_0 out in0 gnd gnd n W='0.46*1u' L=ln_min
M_1_1 out in1 gnd gnd n W='0.46*1u' L=ln_min
M_2_1 out in0 net_1 vdd p W='1.84*1u' L=lp_min
M_3_1 net_1 in1 vdd vdd p W='1.84*1u' L=lp_min
.ENDS	$ MMI_NOR2A
