*** Extracted spice netlist generated from MAX ***

.SUBCKT MMI_42ADD Carry_H Cin_L Cout_L In1_H In2_H In3_H In4_H Sum_H
C_1 vdd gnd 19.4906fF
C_2 In1_H gnd 14.8393fF
C_3 net_1 gnd 2.72823fF
C_4 In3_H gnd 13.8408fF
C_5 Cout_L gnd 5.08021fF
C_6 In2_H gnd 13.0294fF
C_7 In4_H gnd 11.3318fF
C_8 net_2 gnd 5.1806fF
C_9 In3_XNOR_In4 gnd 5.4457fF
C_10 net_3 gnd 4.02687fF
C_11 In3_XOR_In4 gnd 4.88307fF
C_12 gnd gnd 19.0655fF
C_13 net_4 gnd 0.82904fF
C_14 net_5 gnd 0.8558fF
C_15 net_6 gnd 2.1759fF
C_16 net_7 gnd 7.61924fF
C_17 In1_XOR_In2 gnd 3.24548fF
C_18 odd_inputs gnd 5.49319fF
C_19 In1_XNOR_In2 gnd 6.26604fF
C_20 even_inputs gnd 5.82849fF
C_21 net_8 gnd 2.4601fF
C_22 net_9 gnd 5.33066fF
C_23 Carry_H gnd 2.25946fF
C_24 net_14 gnd 2.94869fF
C_25 net_15 gnd 3.6681fF
C_26 net_16 gnd 2.43603fF
C_27 net_17 gnd 3.67338fF
C_28 net_18 gnd 3.80579fF
C_29 Cin_L gnd 5.87502fF
C_30 net_19 gnd 2.61963fF
C_31 Sum_H gnd 2.25946fF
Mp_1 vdd In1_H net_1 vdd p W=2.28U L=0.18U AD=0.75968P PD=3.79986U
+ AS=0.6156P PS=2.82U
Mp_2 net_1 In3_H Cout_L vdd p W=2.28U L=0.18U AD=0.6156P PD=2.82U
+ AS=0.6156P PS=2.82U
Mp_3 Cout_L In3_H net_1 vdd p W=2.28U L=0.18U AD=0.6156P PD=2.82U
+ AS=0.6156P PS=2.82U
Mp_4 net_1 In1_H vdd vdd p W=2.28U L=0.18U AD=0.6156P PD=2.82U AS=0.75968P
+ PS=3.79986U
Mp_5 vdd In2_H net_1 vdd p W=2.28U L=0.18U AD=0.75968P PD=3.79986U
+ AS=0.6156P PS=2.82U
Mp_6 net_1 In4_H Cout_L vdd p W=2.28U L=0.18U AD=0.6156P PD=2.82U
+ AS=0.6156P PS=2.82U
Mp_7 Cout_L In4_H net_1 vdd p W=2.28U L=0.18U AD=0.6156P PD=2.82U
+ AS=0.6156P PS=2.82U
Mp_8 net_1 In2_H vdd vdd p W=2.28U L=0.18U AD=0.6156P PD=2.82U AS=0.75968P
+ PS=3.79986U
Mp_9 vdd In4_H net_2 vdd p W=2.2U L=0.18U AD=0.733024P PD=3.66653U
+ AS=0.867778P PS=4.11481U
Mp_10 net_2 In4_H vdd vdd p W=2.2U L=0.18U AD=0.867778P PD=4.11481U
+ AS=0.733024P PS=3.66653U
Mp_11 net_2 In3_H In3_XNOR_In4 vdd p W=3.2U L=0.18U AD=1.26222P PD=5.98519U
+ AS=1.088P PS=5.26667U
Mp_12 In3_XNOR_In4 net_3 In4_H vdd p W=3.2U L=0.18U AD=1.088P PD=5.26667U
+ AS=1.104P PS=3.89U
Mp_13 In4_H In3_H In3_XOR_In4 vdd p W=3.2U L=0.18U AD=1.104P PD=3.89U
+ AS=0.864P PS=3.92U
Mp_14 In3_XOR_In4 net_3 net_2 vdd p W=3.2U L=0.18U AD=0.864P PD=3.92U
+ AS=1.26222P PS=5.98519U
Mp_15 net_3 In3_H vdd vdd p W=2.4U L=0.18U AD=1.152P PD=5.76U AS=0.799663P
+ PS=3.99985U
Mn_1 gnd In1_H net_4 gnd n W=1.38U L=0.18U AD=0.601369P PD=3.29625U
+ AS=0.3726P PS=1.92U
Mn_2 net_4 In2_H Cout_L gnd n W=1.38U L=0.18U AD=0.3726P PD=1.92U
+ AS=0.3726P PS=1.92U
Mn_3 Cout_L In2_H net_4 gnd n W=1.38U L=0.18U AD=0.3726P PD=1.92U
+ AS=0.3726P PS=1.92U
Mn_4 net_4 In1_H gnd gnd n W=1.38U L=0.18U AD=0.3726P PD=1.92U AS=0.601369P
+ PS=3.29625U
Mn_5 gnd In3_H net_5 gnd n W=1.38U L=0.18U AD=0.601369P PD=3.29625U
+ AS=0.414P PS=1.98U
Mn_6 net_5 In4_H Cout_L gnd n W=1.38U L=0.18U AD=0.414P PD=1.98U AS=0.3726P
+ PS=1.92U
Mn_7 Cout_L In4_H net_5 gnd n W=1.38U L=0.18U AD=0.3726P PD=1.92U AS=0.414P
+ PS=1.98U
Mn_8 net_5 In3_H gnd gnd n W=1.38U L=0.18U AD=0.414P PD=1.98U AS=0.601369P
+ PS=3.29625U
Mn_9 gnd In4_H net_2 gnd n W=2.2U L=0.18U AD=0.958704P PD=5.25489U
+ AS=1.0635P PS=6.67333U
Mn_10 net_2 net_3 In3_XNOR_In4 gnd n W=1.6U L=0.18U AD=0.773452P
+ PD=4.85333U AS=0.544P PS=3.13333U
Mn_11 In3_XNOR_In4 In3_H In4_H gnd n W=1.6U L=0.18U AD=0.544P PD=3.13333U
+ AS=0.552P PS=2.29U
Mn_12 In4_H net_3 In3_XOR_In4 gnd n W=1.6U L=0.18U AD=0.552P PD=2.29U
+ AS=0.432P PS=2.32U
Mn_13 In3_XOR_In4 In3_H net_2 gnd n W=1.6U L=0.18U AD=0.432P PD=2.32U
+ AS=0.773452P PS=4.85333U
Mn_14 net_3 In3_H gnd gnd n W=1.2U L=0.18U AD=0.576P PD=3.36U AS=0.522929P
+ PS=2.8663U
Mn_15 gnd In1_H net_6 gnd n W=0.92U L=0.18U AD=0.400912P PD=2.1975U
+ AS=0.2796P PS=2.08U
Mn_16 net_6 In3_H net_7 gnd n W=0.92U L=0.18U AD=0.2796P PD=2.08U
+ AS=0.2484P PS=1.46U
Mn_17 net_7 In3_H net_6 gnd n W=0.92U L=0.18U AD=0.2484P PD=1.46U
+ AS=0.2796P PS=2.08U
Mn_18 net_6 In1_H gnd gnd n W=0.92U L=0.18U AD=0.2796P PD=2.08U
+ AS=0.400913P PS=2.1975U
Mn_19 gnd In2_H net_6 gnd n W=0.92U L=0.18U AD=0.400913P PD=2.1975U
+ AS=0.2796P PS=2.08U
Mn_20 net_6 In4_H net_7 gnd n W=0.92U L=0.18U AD=0.2796P PD=2.08U
+ AS=0.2484P PS=1.46U
Mn_21 net_7 In4_H net_6 gnd n W=0.92U L=0.18U AD=0.2484P PD=1.46U
+ AS=0.2796P PS=2.08U
Mn_22 net_6 In2_H gnd gnd n W=0.92U L=0.18U AD=0.2796P PD=2.08U
+ AS=0.400912P PS=2.1975U
Mn_23 In3_XNOR_In4 In1_XOR_In2 odd_inputs gnd n W=0.8U L=0.18U AD=0.272P
+ PD=1.56667U AS=0.216P PS=1.34U
Mn_24 odd_inputs In1_XNOR_In2 In3_XOR_In4 gnd n W=0.8U L=0.18U AD=0.216P
+ PD=1.34U AS=0.216P PS=1.16U
Mn_25 In3_XOR_In4 In1_XOR_In2 even_inputs gnd n W=0.8U L=0.18U AD=0.216P
+ PD=1.16U AS=0.216P PS=1.34U
Mn_26 even_inputs In1_XNOR_In2 In3_XNOR_In4 gnd n W=0.8U L=0.18U AD=0.216P
+ PD=1.34U AS=0.272P PS=1.56667U
Mn_27 net_8 In1_H In1_XOR_In2 gnd n W=0.8U L=0.18U AD=0.272P PD=1.74667U
+ AS=0.216P PS=1.34U
Mn_28 In1_XOR_In2 net_9 In2_H gnd n W=0.8U L=0.18U AD=0.216P PD=1.34U
+ AS=0.216P PS=1.34U
Mn_29 In2_H In1_H In1_XNOR_In2 gnd n W=0.8U L=0.18U AD=0.216P PD=1.34U
+ AS=0.216P PS=1.34U
Mn_30 In1_XNOR_In2 net_9 net_8 gnd n W=0.8U L=0.18U AD=0.216P PD=1.34U
+ AS=0.272P PS=1.74667U
Mn_31 net_8 In2_H gnd gnd n W=0.8U L=0.18U AD=0.272P PD=1.74667U
+ AS=0.34862P PS=1.91087U
Mn_32 gnd In1_H net_9 gnd n W=0.8U L=0.18U AD=0.34862P PD=1.91087U
+ AS=0.384P PS=2.56U
Mp_16 net_7 In2_H net_10 vdd p W=1.84U L=0.18U AD=0.69P PD=3.51U AS=0.3588P
+ PS=2.23U
Mp_17 net_10 In1_H vdd vdd p W=1.84U L=0.18U AD=0.3588P PD=2.23U
+ AS=0.613075P PS=3.06655U
Mp_18 vdd In1_H net_11 vdd p W=1.84U L=0.18U AD=0.613075P PD=3.06655U
+ AS=0.3588P PS=2.23U
Mp_19 net_11 In2_H net_7 vdd p W=1.84U L=0.18U AD=0.3588P PD=2.23U AS=0.69P
+ PS=3.51U
Mp_20 net_7 In4_H net_12 vdd p W=1.84U L=0.18U AD=0.69P PD=3.51U AS=0.3588P
+ PS=2.23U
Mp_21 net_12 In3_H vdd vdd p W=1.84U L=0.18U AD=0.3588P PD=2.23U
+ AS=0.613075P PS=3.06655U
Mp_22 vdd In3_H net_13 vdd p W=1.84U L=0.18U AD=0.613075P PD=3.06655U
+ AS=0.3588P PS=2.23U
Mp_23 net_13 In4_H net_7 vdd p W=1.84U L=0.18U AD=0.3588P PD=2.23U AS=0.69P
+ PS=3.51U
Mp_24 In3_XNOR_In4 In1_XNOR_In2 odd_inputs vdd p W=1.6U L=0.18U AD=0.544P
+ PD=2.63333U AS=0.432P PS=2.14U
Mp_25 odd_inputs In1_XOR_In2 In3_XOR_In4 vdd p W=1.6U L=0.18U AD=0.432P
+ PD=2.14U AS=0.432P PS=1.96U
Mp_26 In3_XOR_In4 In1_XNOR_In2 even_inputs vdd p W=1.6U L=0.18U AD=0.432P
+ PD=1.96U AS=0.432P PS=2.14U
Mp_27 even_inputs In1_XOR_In2 In3_XNOR_In4 vdd p W=1.6U L=0.18U AD=0.432P
+ PD=2.14U AS=0.544P PS=2.63333U
Mp_28 net_8 net_9 In1_XOR_In2 vdd p W=1.6U L=0.18U AD=0.544P PD=2.81333U
+ AS=0.432P PS=2.14U
Mp_29 In1_XOR_In2 In1_H In2_H vdd p W=1.6U L=0.18U AD=0.432P PD=2.14U
+ AS=0.432P PS=2.14U
Mp_30 In2_H net_9 In1_XNOR_In2 vdd p W=1.6U L=0.18U AD=0.432P PD=2.14U
+ AS=0.432P PS=2.14U
Mp_31 In1_XNOR_In2 In1_H net_8 vdd p W=1.6U L=0.18U AD=0.432P PD=2.14U
+ AS=0.544P PS=2.81333U
Mp_32 net_8 In2_H vdd vdd p W=1.6U L=0.18U AD=0.544P PD=2.81333U
+ AS=0.533109P PS=2.66657U
Mp_33 vdd In1_H net_9 vdd p W=1.6U L=0.18U AD=0.533109P PD=2.66657U
+ AS=0.768P PS=4.16U
Mp_34 Carry_H net_14 vdd vdd p W=2.455U L=0.18U AD=0.8347P PD=3.95333U
+ AS=0.817988P PS=4.09151U
Mp_35 vdd net_14 Carry_H vdd p W=2.455U L=0.18U AD=0.817988P PD=4.09151U
+ AS=0.8347P PS=3.95333U
Mp_36 Carry_H net_14 vdd vdd p W=2.455U L=0.18U AD=0.8347P PD=3.95333U
+ AS=0.817988P PS=4.09151U
Mp_37 vdd net_15 net_14 vdd p W=2.48U L=0.18U AD=0.826318P PD=4.13318U
+ AS=1.1904P PS=5.92U
Mp_38 vdd net_7 net_16 vdd p W=2.2U L=0.18U AD=0.733024P PD=3.66653U
+ AS=0.7172P PS=3.53467U
Mp_39 net_16 net_7 vdd vdd p W=2.2U L=0.18U AD=0.7172P PD=3.53467U
+ AS=0.733024P PS=3.66653U
Mp_40 net_16 odd_inputs net_15 vdd p W=1.6U L=0.18U AD=0.5216P PD=2.57067U
+ AS=0.432P PS=2.14U
Mp_41 net_15 even_inputs net_17 vdd p W=1.6U L=0.18U AD=0.432P PD=2.14U
+ AS=0.432P PS=2.14U
Mp_42 net_17 odd_inputs net_18 vdd p W=1.6U L=0.18U AD=0.432P PD=2.14U
+ AS=0.432P PS=2.14U
Mp_43 net_18 even_inputs Cin_L vdd p W=1.6U L=0.18U AD=0.432P PD=2.14U
+ AS=0.768P PS=4.16U
Mp_44 vdd Cin_L net_17 vdd p W=1.6U L=0.18U AD=0.533109P PD=2.66657U
+ AS=0.432P PS=2.14U
Mp_45 net_17 Cin_L vdd vdd p W=1.6U L=0.18U AD=0.432P PD=2.14U AS=0.533109P
+ PS=2.66657U
Mp_46 net_19 net_18 vdd vdd p W=1.86U L=0.18U AD=0.8928P PD=4.68U
+ AS=0.619739P PS=3.09988U
Mp_47 vdd net_19 Sum_H vdd p W=2.455U L=0.18U AD=0.817988P PD=4.09151U
+ AS=0.8347P PS=3.95333U
Mp_48 Sum_H net_19 vdd vdd p W=2.455U L=0.18U AD=0.8347P PD=3.95333U
+ AS=0.817988P PS=4.09151U
Mp_49 vdd net_19 Sum_H vdd p W=2.455U L=0.18U AD=0.817988P PD=4.09151U
+ AS=0.8347P PS=3.95333U
Mn_33 gnd net_14 Carry_H gnd n W=1.84U L=0.18U AD=0.801825P PD=4.395U
+ AS=0.4968P PS=2.38U
Mn_34 Carry_H net_14 gnd gnd n W=1.84U L=0.18U AD=0.4968P PD=2.38U
+ AS=0.801825P PS=4.395U
Mn_35 net_14 net_15 gnd gnd n W=1.24U L=0.18U AD=0.5952P PD=3.44U
+ AS=0.54036P PS=2.96185U
Mn_36 gnd net_7 net_16 gnd n W=2.2U L=0.18U AD=0.958704P PD=5.25489U
+ AS=1.056P PS=5.808U
Mn_37 net_16 even_inputs net_15 gnd n W=0.8U L=0.18U AD=0.384P PD=2.112U
+ AS=0.216P PS=1.34U
Mn_38 net_15 odd_inputs net_17 gnd n W=0.8U L=0.18U AD=0.216P PD=1.34U
+ AS=0.216P PS=1.16U
Mn_39 net_17 even_inputs net_18 gnd n W=0.8U L=0.18U AD=0.216P PD=1.16U
+ AS=0.216P PS=1.34U
Mn_40 net_18 odd_inputs Cin_L gnd n W=0.8U L=0.18U AD=0.216P PD=1.34U
+ AS=0.384P PS=2.56U
Mn_41 gnd Cin_L net_17 gnd n W=1.6U L=0.18U AD=0.697239P PD=3.82174U
+ AS=0.432P PS=2.32U
Mn_42 net_17 Cin_L gnd gnd n W=1.6U L=0.18U AD=0.432P PD=2.32U AS=0.697239P
+ PS=3.82174U
Mn_43 gnd net_18 net_19 gnd n W=1.24U L=0.18U AD=0.54036P PD=2.96185U
+ AS=0.5952P PS=3.44U
Mn_44 gnd net_19 Sum_H gnd n W=1.84U L=0.18U AD=0.801825P PD=4.395U
+ AS=0.4968P PS=2.38U
Mn_45 Sum_H net_19 gnd gnd n W=1.84U L=0.18U AD=0.4968P PD=2.38U
+ AS=0.801825P PS=4.395U
.ENDS	$ MMI_42ADD

.GLOBAL gnd vdd
