* FILE: MMI_CLKBUFE.sp

* SPICE netlist for "MMI_CLKBUFE" (generated by MMI_SUE4.1.5)

.SUBCKT inverter in out WP=2 LP=lp_min WN=1 LN=ln_min
M_0 out in gnd gnd n W='WN*1u' L=LN ad='arean(WN,sdd)' as='arean(WN,sdd)'
+ pd='perin(WN,sdd)' ps='perin(WN,sdd)'
M_1 out in vdd vdd p W='WP*1u' L=LP ad='areap(WP,sdd)' as='areap(WP,sdd)'
+ pd='perip(WP,sdd)' ps='perip(WP,sdd)'
.ENDS	$ inverter

.SUBCKT inverter1 in out WP=2 LP=lp_min WN=1 LN=ln_min
M_0 out in gnd gnd n W='WN*1u' L=LN ad='arean(WN,sdd)' as='arean(WN,sdd)'
+ pd='perin(WN,sdd)' ps='perin(WN,sdd)'
M_1 out in vdd vdd p W='WP*1u' L=LP ad='areap(WP,sdd)' as='areap(WP,sdd)'
+ pd='perip(WP,sdd)' ps='perip(WP,sdd)'
.ENDS	$ inverter1

.SUBCKT MMI_CLKBUFE clk g_clk g_scan_en scan_en scan_in scan_out
Xinverter scan_in scan_in_L inverter WP=1.6 WN=0.8
Xinverter1 scan_in_L scan_out inverter1 WP=4.8 WN=2.4
Xinverter_1 g_scan_en g_scan_en_L inverter WP=1.6 WN=0.8
Xinverter1_1 g_scan_en_L scan_en inverter1 WP=4.8 WN=2.4
Xinverter_2 g_clk g_clk_L inverter WP=6.4 WN=3.2
Xinverter1_2 g_clk_L clk inverter1 WP=19.2 WN=9.6
.ENDS	$ MMI_CLKBUFE

.GLOBAL gnd vdd
