* FILE: MMI_OR3C.sp

* SPICE netlist for "MMI_OR3C" (generated by MMI_SUE4.1.5)

.SUBCKT inverter1 in out WP=2 LP=lp_min WN=1 LN=ln_min
M_0 out in gnd gnd n W='WN*1u' L=LN ad='arean(WN,sdd)' as='arean(WN,sdd)'
+ pd='perin(WN,sdd)' ps='perin(WN,sdd)'
M_1 out in vdd vdd p W='WP*1u' L=LP ad='areap(WP,sdd)' as='areap(WP,sdd)'
+ pd='perip(WP,sdd)' ps='perip(WP,sdd)'
.ENDS	$ inverter1

.SUBCKT MMI_OR3C in0 in1 in2 out
Xinverter1 N1 out inverter1 WP=3.68 WN=1.84
M_0 N1 in2 gnd gnd n W='0.62*1u' L=ln_min ad='arean(0.62,sdd)'
+ as='arean(0.62,sdd)' pd='perin(0.62,sdd)' ps='perin(0.62,sdd)'
M_1 N1 in1 gnd gnd n W='0.62*1u' L=ln_min ad='arean(0.62,sdd)'
+ as='arean(0.62,sdd)' pd='perin(0.62,sdd)' ps='perin(0.62,sdd)'
M_2 N1 in0 gnd gnd n W='0.62*1u' L=ln_min ad='arean(0.62,sdd)'
+ as='arean(0.62,sdd)' pd='perin(0.62,sdd)' ps='perin(0.62,sdd)'
M_3 N1 in0 net_1 vdd p W='1.86*1u' L=lp_min ad='areap(1.86,sdd)'
+ as='areap(1.86,sdd)' pd='perip(1.86,sdd)' ps='perip(1.86,sdd)'
M_4 N1 in0 net_2 vdd p W='1.86*1u' L=lp_min ad='areap(1.86,sdd)'
+ as='areap(1.86,sdd)' pd='perip(1.86,sdd)' ps='perip(1.86,sdd)'
M_5 net_2 in1 net_3 vdd p W='1.86*1u' L=lp_min ad='areap(1.86,sdd)'
+ as='areap(1.86,sdd)' pd='perip(1.86,sdd)' ps='perip(1.86,sdd)'
M_6 net_1 in1 net_4 vdd p W='1.86*1u' L=lp_min ad='areap(1.86,sdd)'
+ as='areap(1.86,sdd)' pd='perip(1.86,sdd)' ps='perip(1.86,sdd)'
M_7 net_4 in2 vdd vdd p W='1.86*1u' L=lp_min ad='areap(1.86,sdd)'
+ as='areap(1.86,sdd)' pd='perip(1.86,sdd)' ps='perip(1.86,sdd)'
M_8 net_3 in2 vdd vdd p W='1.86*1u' L=lp_min ad='areap(1.86,sdd)'
+ as='areap(1.86,sdd)' pd='perip(1.86,sdd)' ps='perip(1.86,sdd)'
.ENDS	$ MMI_OR3C

.GLOBAL gnd vdd
