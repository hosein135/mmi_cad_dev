* FILE: MMI_MUX2B.sp

* SPICE netlist for "MMI_MUX2B" (generated by MMI_SUE4.1.5)

.SUBCKT inverter in out WP=2 LP=lp_min WN=1 LN=ln_min
M_0 out in gnd gnd n W='WN*1u' L=LN ad='arean(WN,sdd)' as='arean(WN,sdd)'
+ pd='perin(WN,sdd)' ps='perin(WN,sdd)'
M_1 out in vdd vdd p W='WP*1u' L=LP ad='areap(WP,sdd)' as='areap(WP,sdd)'
+ pd='perip(WP,sdd)' ps='perip(WP,sdd)'
.ENDS	$ inverter

.SUBCKT xgate in in_L t1 t2 WP=2 WN=1
M_0 t2 in_L t1 vdd p W='WP*1u' L=lp_min ad='areap(WP,sdd)'
+ as='areap(WP,sdd)' pd='perip(WP,sdd)' ps='perip(WP,sdd)'
M_1 t2 in t1 gnd n W='WN*1u' L=ln_min ad='arean(WN,sdd)' as='arean(WN,sdd)'
+ pd='perin(WN,sdd)' ps='perin(WN,sdd)'
.ENDS	$ xgate

.SUBCKT MMI_MUX2B in0 in1 out sel
Xinverter net_1 out inverter WP=1.84 WN=0.92
Xxgate net_2 sel net_3 net_1 xgate WP=1.84 WN=0.92
Xinverter_1 in0 net_3 inverter WP=1.84 WN=0.92
Xxgate_1 sel net_2 net_4 net_1 xgate WP=1.84 WN=0.92
Xinverter_2 in1 net_4 inverter WP=1.84 WN=0.92
Xinverter_3 sel net_2 inverter WP=0.92 WN=0.46
.ENDS	$ MMI_MUX2B

.GLOBAL gnd vdd
