* FILE: MMI_XNOR2A.sp

* SPICE netlist for "MMI_XNOR2A" (generated by MMI_SUE4.1.5)

.SUBCKT MMI_NAND2A in0 in1 out
M_0 net_1 in1 gnd gnd n W='.92*1u' L=ln_min ad='arean(.92,sdd)'
+ as='arean(.92,sdd)' pd='perin(.92,sdd)' ps='perin(.92,sdd)'
M_1 out in0 net_1 gnd n W='.92*1u' L=ln_min ad='arean(.92,sdd)'
+ as='arean(.92,sdd)' pd='perin(.92,sdd)' ps='perin(.92,sdd)'
M_2 out in1 vdd vdd p W='.92*1u' L=lp_min ad='areap(.92,sdd)'
+ as='areap(.92,sdd)' pd='perip(.92,sdd)' ps='perip(.92,sdd)'
M_3 out in0 vdd vdd p W='.92*1u' L=lp_min ad='areap(.92,sdd)'
+ as='areap(.92,sdd)' pd='perip(.92,sdd)' ps='perip(.92,sdd)'
.ENDS	$ MMI_NAND2A

.SUBCKT MMI_OAI21A in0 in1 in2 out
M_0 out in0 net_1 gnd n W='.92*1u' L=ln_min ad='arean(.92,sdd)'
+ as='arean(.92,sdd)' pd='perin(.92,sdd)' ps='perin(.92,sdd)'
M_1 net_1 in1 gnd gnd n W='.92*1u' L=ln_min ad='arean(.92,sdd)'
+ as='arean(.92,sdd)' pd='perin(.92,sdd)' ps='perin(.92,sdd)'
M_2 net_1 in2 gnd gnd n W='.92*1u' L=ln_min ad='arean(.92,sdd)'
+ as='arean(.92,sdd)' pd='perin(.92,sdd)' ps='perin(.92,sdd)'
M_3 out in0 vdd vdd p W='.92*1u' L=lp_min ad='areap(.92,sdd)'
+ as='areap(.92,sdd)' pd='perip(.92,sdd)' ps='perip(.92,sdd)'
M_4 out in1 net_2 vdd p W='1.84*1u' L=lp_min ad='areap(1.84,sdd)'
+ as='areap(1.84,sdd)' pd='perip(1.84,sdd)' ps='perip(1.84,sdd)'
M_5 net_2 in2 vdd vdd p W='1.84*1u' L=lp_min ad='areap(1.84,sdd)'
+ as='areap(1.84,sdd)' pd='perip(1.84,sdd)' ps='perip(1.84,sdd)'
.ENDS	$ MMI_OAI21A

.SUBCKT MMI_XNOR2A in0 in1 out
XMMI_NAND2A in0 in1 net_1 MMI_NAND2A
XMMI_OAI21A net_1 in1 in0 out MMI_OAI21A
.ENDS	$ MMI_XNOR2A

.GLOBAL gnd vdd
