* FILE: MMI_MUX4B.sp

* SPICE netlist for "MMI_MUX4B" (generated by MMI_SUE4.1.5)

.SUBCKT xgate in in_L t1 t2 WP=2 WN=1
M_0 t2 in_L t1 vdd p W='WP*1u' L=lp_min ad='areap(WP,sdd)'
+ as='areap(WP,sdd)' pd='perip(WP,sdd)' ps='perip(WP,sdd)'
M_1 t2 in t1 gnd n W='WN*1u' L=ln_min ad='arean(WN,sdd)' as='arean(WN,sdd)'
+ pd='perin(WN,sdd)' ps='perin(WN,sdd)'
.ENDS	$ xgate

.SUBCKT inverter in out WP=2 LP=lp_min WN=1 LN=ln_min
M_0 out in gnd gnd n W='WN*1u' L=LN ad='arean(WN,sdd)' as='arean(WN,sdd)'
+ pd='perin(WN,sdd)' ps='perin(WN,sdd)'
M_1 out in vdd vdd p W='WP*1u' L=LP ad='areap(WP,sdd)' as='areap(WP,sdd)'
+ pd='perip(WP,sdd)' ps='perip(WP,sdd)'
.ENDS	$ inverter

.SUBCKT MMI_MUX4B in0 in1 in2 in3 out sel0 sel1
Xxgate sel1_L sel1 N1 N2 xgate WP=1.84 WN=0.92
Xxgate_1 sel1 sel1_L net_1 N2 xgate WP=1.84 WN=0.92
Xinverter sel1 sel1_L inverter WP=0.92 WN=0.46
Xxgate_2 net_2 sel0 net_3 N1 xgate WP=1.84 WN=0.92
Xinverter_1 in0 net_3 inverter WP=1.84 WN=0.92
Xxgate_3 sel0 net_2 net_4 N1 xgate WP=1.84 WN=0.92
Xinverter_2 in1 net_4 inverter WP=1.84 WN=0.92
Xxgate_4 net_2 sel0 net_5 net_1 xgate WP=1.84 WN=0.92
Xinverter_3 in2 net_5 inverter WP=1.84 WN=0.92
Xxgate_5 sel0 net_2 net_6 net_1 xgate WP=1.84 WN=0.92
Xinverter_4 in3 net_6 inverter WP=1.84 WN=0.92
Xinverter_5 sel0 net_2 inverter WP=1.24 WN=0.62
Xinverter_6 N2 out inverter WP=1.84 WN=0.92
.ENDS	$ MMI_MUX4B

.GLOBAL gnd vdd
