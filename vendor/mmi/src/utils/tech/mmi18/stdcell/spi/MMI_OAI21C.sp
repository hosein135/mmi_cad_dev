* FILE: MMI_OAI21C.sp

* SPICE netlist for "MMI_OAI21C" (generated by MMI_SUE4.1.5)

.SUBCKT MMI_OAI21C in0 in1 in2 out
M_0 out in0 net_1 gnd n W='3.68*1u' L=ln_min ad='arean(3.68,sdd)'
+ as='arean(3.68,sdd)' pd='perin(3.68,sdd)' ps='perin(3.68,sdd)'
M_1 net_1 in1 gnd gnd n W='3.68*1u' L=ln_min ad='arean(3.68,sdd)'
+ as='arean(3.68,sdd)' pd='perin(3.68,sdd)' ps='perin(3.68,sdd)'
M_2 net_1 in2 gnd gnd n W='3.68*1u' L=ln_min ad='arean(3.68,sdd)'
+ as='arean(3.68,sdd)' pd='perin(3.68,sdd)' ps='perin(3.68,sdd)'
M_3 out in0 vdd vdd p W='3.68*1u' L=lp_min ad='areap(3.68,sdd)'
+ as='areap(3.68,sdd)' pd='perip(3.68,sdd)' ps='perip(3.68,sdd)'
M_4 out in1 net_2 vdd p W='1.84*1u' L=lp_min ad='areap(1.84,sdd)'
+ as='areap(1.84,sdd)' pd='perip(1.84,sdd)' ps='perip(1.84,sdd)'
M_5 out in1 net_3 vdd p W='1.84*1u' L=lp_min ad='areap(1.84,sdd)'
+ as='areap(1.84,sdd)' pd='perip(1.84,sdd)' ps='perip(1.84,sdd)'
M_6 out in1 net_4 vdd p W='1.84*1u' L=lp_min ad='areap(1.84,sdd)'
+ as='areap(1.84,sdd)' pd='perip(1.84,sdd)' ps='perip(1.84,sdd)'
M_7 out in1 net_5 vdd p W='1.84*1u' L=lp_min ad='areap(1.84,sdd)'
+ as='areap(1.84,sdd)' pd='perip(1.84,sdd)' ps='perip(1.84,sdd)'
M_8 net_2 in2 vdd vdd p W='1.84*1u' L=lp_min ad='areap(1.84,sdd)'
+ as='areap(1.84,sdd)' pd='perip(1.84,sdd)' ps='perip(1.84,sdd)'
M_9 net_3 in2 vdd vdd p W='1.84*1u' L=lp_min ad='areap(1.84,sdd)'
+ as='areap(1.84,sdd)' pd='perip(1.84,sdd)' ps='perip(1.84,sdd)'
M_10 net_4 in2 vdd vdd p W='1.84*1u' L=lp_min ad='areap(1.84,sdd)'
+ as='areap(1.84,sdd)' pd='perip(1.84,sdd)' ps='perip(1.84,sdd)'
M_11 net_5 in2 vdd vdd p W='1.84*1u' L=lp_min ad='areap(1.84,sdd)'
+ as='areap(1.84,sdd)' pd='perip(1.84,sdd)' ps='perip(1.84,sdd)'
.ENDS	$ MMI_OAI21C

.GLOBAL gnd vdd
