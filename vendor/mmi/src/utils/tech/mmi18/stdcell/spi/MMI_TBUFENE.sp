* FILE: MMI_TBUFENE.sp

* SPICE netlist for "MMI_TBUFENE" (generated by MMI_SUE4.1.7)

.SUBCKT inverter in out WP=2 LP=lp_min WN=1 LN=ln_min
M_0 out in gnd gnd n W='WN*1u' L=LN ad='arean(WN,sdd)' as='arean(WN,sdd)'
+ pd='perin(WN,sdd)' ps='perin(WN,sdd)'
M_1 out in vdd vdd p W='WP*1u' L=LP ad='areap(WP,sdd)' as='areap(WP,sdd)'
+ pd='perip(WP,sdd)' ps='perip(WP,sdd)'
.ENDS	$ inverter

.SUBCKT nor2 in0 in1 out WP=4 WN=1
M_0 out in1 gnd gnd n W='WN*1u' L=ln_min ad='arean(WN,sdd)'
+ as='arean(WN,sdd)' pd='perin(WN,sdd)' ps='perin(WN,sdd)'
M_1 out in1 net_1 vdd p W='WP*1u' L=lp_min ad='areap(WP,sdd)'
+ as='areap(WP,sdd)' pd='perip(WP,sdd)' ps='perip(WP,sdd)'
M_2 out in0 gnd gnd n W='WN*1u' L=ln_min ad='arean(WN,sdd)'
+ as='arean(WN,sdd)' pd='perin(WN,sdd)' ps='perin(WN,sdd)'
M_3 net_1 in0 vdd vdd p W='WP*1u' L=lp_min ad='areap(WP,sdd)'
+ as='areap(WP,sdd)' pd='perip(WP,sdd)' ps='perip(WP,sdd)'
.ENDS	$ nor2

.SUBCKT xgate in in_L t1 t2 WP=2 WN=1
M_0 t2 in_L t1 vdd p W='WP*1u' L=lp_min ad='areap(WP,sdd)'
+ as='areap(WP,sdd)' pd='perip(WP,sdd)' ps='perip(WP,sdd)'
M_1 t2 in t1 gnd n W='WN*1u' L=ln_min ad='arean(WN,sdd)' as='arean(WN,sdd)'
+ pd='perin(WN,sdd)' ps='perin(WN,sdd)'
.ENDS	$ xgate

.SUBCKT nand2 in0 in1 out WP=2 WN=2
M_0 out in0 vdd vdd p W='WP*1u' L=lp_min ad='areap(WP,sdd)'
+ as='areap(WP,sdd)' pd='perip(WP,sdd)' ps='perip(WP,sdd)'
M_1 out in0 net_1 gnd n W='WN*1u' L=ln_min ad='arean(WN,sdd)'
+ as='arean(WN,sdd)' pd='perin(WN,sdd)' ps='perin(WN,sdd)'
M_2 out in1 vdd vdd p W='WP*1u' L=lp_min ad='areap(WP,sdd)'
+ as='areap(WP,sdd)' pd='perip(WP,sdd)' ps='perip(WP,sdd)'
M_3 net_1 in1 gnd gnd n W='WN*1u' L=ln_min ad='arean(WN,sdd)'
+ as='arean(WN,sdd)' pd='perin(WN,sdd)' ps='perin(WN,sdd)'
.ENDS	$ nand2

.SUBCKT MMI_SFFCB clk clrb d q s_en s_in s_out
Xinverter s_en scan_en_L inverter WP=1.2 WN=0.6
Xinverter_1 N5 q inverter WP=1.84 WN=0.92
M_0 N1 d net_1 vdd p W='1.84*1u' L=lp_min ad='areap(1.84,sdd)'
+ as='areap(1.84,sdd)' pd='perip(1.84,sdd)' ps='perip(1.84,sdd)'
M_1 net_1 s_en vdd vdd p W='1.84*1u' L=lp_min ad='areap(1.84,sdd)'
+ as='areap(1.84,sdd)' pd='perip(1.84,sdd)' ps='perip(1.84,sdd)'
M_2 net_2 scan_en_L gnd gnd n W='0.92*1u' L=ln_min ad='arean(0.92,sdd)'
+ as='arean(0.92,sdd)' pd='perin(0.92,sdd)' ps='perin(0.92,sdd)'
M_3 N1 d net_2 gnd n W='0.92*1u' L=ln_min ad='arean(0.92,sdd)'
+ as='arean(0.92,sdd)' pd='perin(0.92,sdd)' ps='perin(0.92,sdd)'
Xinverter_2 clk clk_L inverter WP=0.92 WN=0.46
M_4 N1 scan_en_L net_3 vdd p W='0.92*1u' L=lp_min ad='areap(0.92,sdd)'
+ as='areap(0.92,sdd)' pd='perip(0.92,sdd)' ps='perip(0.92,sdd)'
M_5 N1 s_en net_4 gnd n W='0.46*1u' L=ln_min ad='arean(0.46,sdd)'
+ as='arean(0.46,sdd)' pd='perin(0.46,sdd)' ps='perin(0.46,sdd)'
M_6 net_4 s_in gnd gnd n W='0.46*1u' L=ln_min ad='arean(0.46,sdd)'
+ as='arean(0.46,sdd)' pd='perin(0.46,sdd)' ps='perin(0.46,sdd)'
M_7 net_3 s_in vdd vdd p W='0.92*1u' L=lp_min ad='areap(0.92,sdd)'
+ as='areap(0.92,sdd)' pd='perip(0.92,sdd)' ps='perip(0.92,sdd)'
M_8 net_5 N5 gnd gnd n W='0.42*1u' L=ln_min ad='arean(0.42,sdd)'
+ as='arean(0.42,sdd)' pd='perin(0.42,sdd)' ps='perin(0.42,sdd)'
M_9 N4 clk net_6 vdd p W='0.42*1u' L=lp_min ad='areap(0.42,sdd)'
+ as='areap(0.42,sdd)' pd='perip(0.42,sdd)' ps='perip(0.42,sdd)'
M_10 N4 clk_L net_5 gnd n W='0.42*1u' L=ln_min ad='arean(0.42,sdd)'
+ as='arean(0.42,sdd)' pd='perin(0.42,sdd)' ps='perin(0.42,sdd)'
M_11 net_6 N5 vdd vdd p W='0.42*1u' L=lp_min ad='areap(0.42,sdd)'
+ as='areap(0.42,sdd)' pd='perip(0.42,sdd)' ps='perip(0.42,sdd)'
M_12 net_7 N3 vdd vdd p W='0.42*1u' L=lp_min ad='areap(0.42,sdd)'
+ as='areap(0.42,sdd)' pd='perip(0.42,sdd)' ps='perip(0.42,sdd)'
M_13 N2 clk_L net_7 vdd p W='0.42*1u' L=lp_min ad='areap(0.42,sdd)'
+ as='areap(0.42,sdd)' pd='perip(0.42,sdd)' ps='perip(0.42,sdd)'
M_14 N2 clk net_8 gnd n W='0.42*1u' L=ln_min ad='arean(0.42,sdd)'
+ as='arean(0.42,sdd)' pd='perin(0.42,sdd)' ps='perin(0.42,sdd)'
M_15 net_8 N3 gnd gnd n W='0.42*1u' L=ln_min ad='arean(0.42,sdd)'
+ as='arean(0.42,sdd)' pd='perin(0.42,sdd)' ps='perin(0.42,sdd)'
Xxgate clk clk_L N3 N4 xgate WP=0.92 WN=0.42
Xxgate_1 clk_L clk N2 N1 xgate WP=0.92 WN=0.42
Xinverter_3 clrb clear inverter WP=1.2 WN=0.6
Xnand2 N4 clrb N5 nand2 WP=0.92 WN=1.24
Xnor2 clear N2 N3 nor2 WP=1.84 WN=0.46
Xnand2_1 N5 s_en s_out nand2 WP=0.84 WN=0.84
.ic N4=0V
.ENDS	$ MMI_SFFCB

.SUBCKT MMI_TBUFENE clk clrb d en enb s_en s_in s_out
Xinverter net_1 net_2 inverter WP=0.92 WN=0.46
Xinverter_1 net_3 net_4 inverter WP=0.92 WN=0.46
Xinverter_2 net_5 net_3 inverter WP=0.92 WN=0.46
Xnor2 net_2 net_5 net_6 nor2 WP=3.2 WN=0.8
Xinverter_3 net_7 net_5 inverter WP=1.24 WN=0.62
Xnor2_1 s_en net_4 net_1 nor2 WP=0.92 WN=0.46
XMMI_SFFCB clk clrb d net_7 s_en s_in s_out MMI_SFFCB
Xinverter_4 net_8 en inverter WP=14.72 WN=7.36
Xinverter_5 net_9 enb inverter WP=14.72 WN=7.36
Xinverter_6 net_10 net_9 inverter WP=4.88 WN=2.44
Xinverter_7 net_6 net_10 inverter WP=1.64 WN=0.82
Xinverter_8 net_6 net_8 inverter WP=2.44 WN=1.22
.ENDS	$ MMI_TBUFENE

.GLOBAL gnd vdd
