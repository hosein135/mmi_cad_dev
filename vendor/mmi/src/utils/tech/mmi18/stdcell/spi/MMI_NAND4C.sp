* FILE: MMI_NAND4C.sp

* SPICE netlist for "MMI_NAND4C" (generated by MMI_SUE4.1.5)

.SUBCKT MMI_NAND4C in0 in1 in2 in3 out
M_0 out in0 vdd vdd p W='1.84*1u' L=lp_min ad='areap(1.84,sdd)'
+ as='areap(1.84,sdd)' pd='perip(1.84,sdd)' ps='perip(1.84,sdd)'
M_1 out in0 vdd vdd p W='1.84*1u' L=lp_min ad='areap(1.84,sdd)'
+ as='areap(1.84,sdd)' pd='perip(1.84,sdd)' ps='perip(1.84,sdd)'
M_2 out in1 vdd vdd p W='1.84*1u' L=lp_min ad='areap(1.84,sdd)'
+ as='areap(1.84,sdd)' pd='perip(1.84,sdd)' ps='perip(1.84,sdd)'
M_3 out in1 vdd vdd p W='1.84*1u' L=lp_min ad='areap(1.84,sdd)'
+ as='areap(1.84,sdd)' pd='perip(1.84,sdd)' ps='perip(1.84,sdd)'
M_4 out in2 vdd vdd p W='1.84*1u' L=lp_min ad='areap(1.84,sdd)'
+ as='areap(1.84,sdd)' pd='perip(1.84,sdd)' ps='perip(1.84,sdd)'
M_5 out in2 vdd vdd p W='1.84*1u' L=lp_min ad='areap(1.84,sdd)'
+ as='areap(1.84,sdd)' pd='perip(1.84,sdd)' ps='perip(1.84,sdd)'
M_6 out in3 vdd vdd p W='1.84*1u' L=lp_min ad='areap(1.84,sdd)'
+ as='areap(1.84,sdd)' pd='perip(1.84,sdd)' ps='perip(1.84,sdd)'
M_7 out in3 vdd vdd p W='1.84*1u' L=lp_min ad='areap(1.84,sdd)'
+ as='areap(1.84,sdd)' pd='perip(1.84,sdd)' ps='perip(1.84,sdd)'
M_8 out in0 net_1 gnd n W='1.84*1u' L=ln_min ad='arean(1.84,sdd)'
+ as='arean(1.84,sdd)' pd='perin(1.84,sdd)' ps='perin(1.84,sdd)'
M_9 out in0 net_2 gnd n W='1.84*1u' L=ln_min ad='arean(1.84,sdd)'
+ as='arean(1.84,sdd)' pd='perin(1.84,sdd)' ps='perin(1.84,sdd)'
M_10 out in0 net_3 gnd n W='1.84*1u' L=ln_min ad='arean(1.84,sdd)'
+ as='arean(1.84,sdd)' pd='perin(1.84,sdd)' ps='perin(1.84,sdd)'
M_11 out in0 net_4 gnd n W='1.84*1u' L=ln_min ad='arean(1.84,sdd)'
+ as='arean(1.84,sdd)' pd='perin(1.84,sdd)' ps='perin(1.84,sdd)'
M_12 net_2 in1 net_5 gnd n W='1.84*1u' L=ln_min ad='arean(1.84,sdd)'
+ as='arean(1.84,sdd)' pd='perin(1.84,sdd)' ps='perin(1.84,sdd)'
M_13 net_5 in2 net_6 gnd n W='1.84*1u' L=ln_min ad='arean(1.84,sdd)'
+ as='arean(1.84,sdd)' pd='perin(1.84,sdd)' ps='perin(1.84,sdd)'
M_14 net_6 in3 gnd gnd n W='1.84*1u' L=ln_min ad='arean(1.84,sdd)'
+ as='arean(1.84,sdd)' pd='perin(1.84,sdd)' ps='perin(1.84,sdd)'
M_15 net_7 in3 gnd gnd n W='1.84*1u' L=ln_min ad='arean(1.84,sdd)'
+ as='arean(1.84,sdd)' pd='perin(1.84,sdd)' ps='perin(1.84,sdd)'
M_16 net_8 in2 net_7 gnd n W='1.84*1u' L=ln_min ad='arean(1.84,sdd)'
+ as='arean(1.84,sdd)' pd='perin(1.84,sdd)' ps='perin(1.84,sdd)'
M_17 net_3 in1 net_8 gnd n W='1.84*1u' L=ln_min ad='arean(1.84,sdd)'
+ as='arean(1.84,sdd)' pd='perin(1.84,sdd)' ps='perin(1.84,sdd)'
M_18 net_4 in1 net_9 gnd n W='1.84*1u' L=ln_min ad='arean(1.84,sdd)'
+ as='arean(1.84,sdd)' pd='perin(1.84,sdd)' ps='perin(1.84,sdd)'
M_19 net_1 in1 net_10 gnd n W='1.84*1u' L=ln_min ad='arean(1.84,sdd)'
+ as='arean(1.84,sdd)' pd='perin(1.84,sdd)' ps='perin(1.84,sdd)'
M_20 net_9 in2 net_11 gnd n W='1.84*1u' L=ln_min ad='arean(1.84,sdd)'
+ as='arean(1.84,sdd)' pd='perin(1.84,sdd)' ps='perin(1.84,sdd)'
M_21 net_10 in2 net_12 gnd n W='1.84*1u' L=ln_min ad='arean(1.84,sdd)'
+ as='arean(1.84,sdd)' pd='perin(1.84,sdd)' ps='perin(1.84,sdd)'
M_22 net_11 in3 gnd gnd n W='1.84*1u' L=ln_min ad='arean(1.84,sdd)'
+ as='arean(1.84,sdd)' pd='perin(1.84,sdd)' ps='perin(1.84,sdd)'
M_23 net_12 in3 gnd gnd n W='1.84*1u' L=ln_min ad='arean(1.84,sdd)'
+ as='arean(1.84,sdd)' pd='perin(1.84,sdd)' ps='perin(1.84,sdd)'
.ENDS	$ MMI_NAND4C

.GLOBAL gnd vdd
