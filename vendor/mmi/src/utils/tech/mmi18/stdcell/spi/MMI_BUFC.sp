* FILE: MMI_BUFC.sp

* SPICE netlist for "MMI_BUFC" (generated by MMI_SUE4.1.5)

.SUBCKT MMI_BUFC in out
M_0 out N1 vdd vdd p W='3.68*1u' L=lp_min ad='areap(3.68,sdd)'
+ as='areap(3.68,sdd)' pd='perip(3.68,sdd)' ps='perip(3.68,sdd)'
M_1 out N1 gnd gnd n W='1.84*1u' L=ln_min ad='arean(1.84,sdd)'
+ as='arean(1.84,sdd)' pd='perin(1.84,sdd)' ps='perin(1.84,sdd)'
M_2 N1 in gnd gnd n W='.62*1u' L=ln_min ad='arean(.62,sdd)'
+ as='arean(.62,sdd)' pd='perin(.62,sdd)' ps='perin(.62,sdd)'
M_3 N1 in vdd vdd p W='1.24*1u' L=lp_min ad='areap(1.24,sdd)'
+ as='areap(1.24,sdd)' pd='perip(1.24,sdd)' ps='perip(1.24,sdd)'
.ENDS	$ MMI_BUFC

.GLOBAL gnd vdd
