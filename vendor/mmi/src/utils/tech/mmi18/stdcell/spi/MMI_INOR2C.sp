* FILE: MMI_INOR2C.sp

* SPICE netlist for "MMI_INOR2C" (generated by MMI_SUE4.1.5)

.SUBCKT inverter in out WP=2 LP=lp_min WN=1 LN=ln_min
M_0 out in gnd gnd n W='WN*1u' L=LN ad='arean(WN,sdd)' as='arean(WN,sdd)'
+ pd='perin(WN,sdd)' ps='perin(WN,sdd)'
M_1 out in vdd vdd p W='WP*1u' L=LP ad='areap(WP,sdd)' as='areap(WP,sdd)'
+ pd='perip(WP,sdd)' ps='perip(WP,sdd)'
.ENDS	$ inverter

.SUBCKT MMI_INOR2C in0 in1 out
M_0 out in1_L gnd gnd n W='1.84*1u' L=ln_min ad='arean(1.84,sdd)'
+ as='arean(1.84,sdd)' pd='perin(1.84,sdd)' ps='perin(1.84,sdd)'
M_1 out in0 gnd gnd n W='1.84*1u' L=ln_min ad='arean(1.84,sdd)'
+ as='arean(1.84,sdd)' pd='perin(1.84,sdd)' ps='perin(1.84,sdd)'
M_2 out in1_L net_1 vdd p W='1.84*1u' L=lp_min ad='areap(1.84,sdd)'
+ as='areap(1.84,sdd)' pd='perip(1.84,sdd)' ps='perip(1.84,sdd)'
M_3 out in1_L net_2 vdd p W='1.84*1u' L=lp_min ad='areap(1.84,sdd)'
+ as='areap(1.84,sdd)' pd='perip(1.84,sdd)' ps='perip(1.84,sdd)'
M_4 out in1_L net_3 vdd p W='1.84*1u' L=lp_min ad='areap(1.84,sdd)'
+ as='areap(1.84,sdd)' pd='perip(1.84,sdd)' ps='perip(1.84,sdd)'
M_5 out in1_L net_4 vdd p W='1.84*1u' L=lp_min ad='areap(1.84,sdd)'
+ as='areap(1.84,sdd)' pd='perip(1.84,sdd)' ps='perip(1.84,sdd)'
M_6 net_4 in0 vdd vdd p W='1.84*1u' L=lp_min ad='areap(1.84,sdd)'
+ as='areap(1.84,sdd)' pd='perip(1.84,sdd)' ps='perip(1.84,sdd)'
M_7 net_3 in0 vdd vdd p W='1.84*1u' L=lp_min ad='areap(1.84,sdd)'
+ as='areap(1.84,sdd)' pd='perip(1.84,sdd)' ps='perip(1.84,sdd)'
M_8 net_2 in0 vdd vdd p W='1.84*1u' L=lp_min ad='areap(1.84,sdd)'
+ as='areap(1.84,sdd)' pd='perip(1.84,sdd)' ps='perip(1.84,sdd)'
M_9 net_1 in0 vdd vdd p W='1.84*1u' L=lp_min ad='areap(1.84,sdd)'
+ as='areap(1.84,sdd)' pd='perip(1.84,sdd)' ps='perip(1.84,sdd)'
Xinverter in1 in1_L inverter WP=1.84 WN=.92
.ENDS	$ MMI_INOR2C

.GLOBAL gnd vdd
