* FILE: MMI_AOI21C.sp

* SPICE netlist for "MMI_AOI21C" (generated by MMI_SUE4.1.5)

.SUBCKT MMI_AOI21C in0 in1 in2 out
M_0 out in0 gnd gnd n W='1.84*1u' L=ln_min ad='arean(1.84,sdd)'
+ as='arean(1.84,sdd)' pd='perin(1.84,sdd)' ps='perin(1.84,sdd)'
M_1 out in1 net_1 gnd n W='3.68*1u' L=ln_min ad='arean(3.68,sdd)'
+ as='arean(3.68,sdd)' pd='perin(3.68,sdd)' ps='perin(3.68,sdd)'
M_2 net_1 in2 gnd gnd n W='3.68*1u' L=ln_min ad='arean(3.68,sdd)'
+ as='arean(3.68,sdd)' pd='perin(3.68,sdd)' ps='perin(3.68,sdd)'
M_3 out in0 net_2 vdd p W='7.36*1u' L=lp_min ad='areap(7.36,sdd)'
+ as='areap(7.36,sdd)' pd='perip(7.36,sdd)' ps='perip(7.36,sdd)'
M_4 net_2 in2 vdd vdd p W='7.36*1u' L=lp_min ad='areap(7.36,sdd)'
+ as='areap(7.36,sdd)' pd='perip(7.36,sdd)' ps='perip(7.36,sdd)'
M_5 net_2 in1 vdd vdd p W='7.36*1u' L=lp_min ad='areap(7.36,sdd)'
+ as='areap(7.36,sdd)' pd='perip(7.36,sdd)' ps='perip(7.36,sdd)'
.ENDS	$ MMI_AOI21C

.GLOBAL gnd vdd
