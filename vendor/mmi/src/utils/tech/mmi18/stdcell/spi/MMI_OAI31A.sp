* FILE: MMI_OAI31A.sp

* SPICE netlist for "MMI_OAI31A" (generated by MMI_SUE4.1.5)

.SUBCKT MMI_OAI31A in0 in1 in2 in3 out
M_0 out in0 net_1 gnd n W='.92*1u' L=ln_min ad='arean(.92,sdd)'
+ as='arean(.92,sdd)' pd='perin(.92,sdd)' ps='perin(.92,sdd)'
M_1 net_1 in1 gnd gnd n W='.92*1u' L=ln_min ad='arean(.92,sdd)'
+ as='arean(.92,sdd)' pd='perin(.92,sdd)' ps='perin(.92,sdd)'
M_2 net_1 in2 gnd gnd n W='.92*1u' L=ln_min ad='arean(.92,sdd)'
+ as='arean(.92,sdd)' pd='perin(.92,sdd)' ps='perin(.92,sdd)'
M_3 net_1 in3 gnd gnd n W='.92*1u' L=ln_min ad='arean(.92,sdd)'
+ as='arean(.92,sdd)' pd='perin(.92,sdd)' ps='perin(.92,sdd)'
M_4 out in0 vdd vdd p W='.92*1u' L=lp_min ad='areap(.92,sdd)'
+ as='areap(.92,sdd)' pd='perip(.92,sdd)' ps='perip(.92,sdd)'
M_5 out in1 net_2 vdd p W='1.38*1u' L=lp_min ad='areap(1.38,sdd)'
+ as='areap(1.38,sdd)' pd='perip(1.38,sdd)' ps='perip(1.38,sdd)'
M_6 out in1 net_3 vdd p W='1.38*1u' L=lp_min ad='areap(1.38,sdd)'
+ as='areap(1.38,sdd)' pd='perip(1.38,sdd)' ps='perip(1.38,sdd)'
M_7 net_2 in2 net_4 vdd p W='1.38*1u' L=lp_min ad='areap(1.38,sdd)'
+ as='areap(1.38,sdd)' pd='perip(1.38,sdd)' ps='perip(1.38,sdd)'
M_8 net_3 in2 net_5 vdd p W='1.38*1u' L=lp_min ad='areap(1.38,sdd)'
+ as='areap(1.38,sdd)' pd='perip(1.38,sdd)' ps='perip(1.38,sdd)'
M_9 net_5 in3 vdd vdd p W='1.38*1u' L=lp_min ad='areap(1.38,sdd)'
+ as='areap(1.38,sdd)' pd='perip(1.38,sdd)' ps='perip(1.38,sdd)'
M_10 net_4 in3 vdd vdd p W='1.38*1u' L=lp_min ad='areap(1.38,sdd)'
+ as='areap(1.38,sdd)' pd='perip(1.38,sdd)' ps='perip(1.38,sdd)'
.ENDS	$ MMI_OAI31A

.GLOBAL gnd vdd
