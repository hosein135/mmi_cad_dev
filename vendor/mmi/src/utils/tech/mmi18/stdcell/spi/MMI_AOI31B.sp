* FILE: MMI_AOI31B.sp

* SPICE netlist for "MMI_AOI31B" (generated by MMI_SUE4.1.5)

.SUBCKT MMI_AOI31B in0 in1 in2 in3 out
M_0 out in0 gnd gnd n W='.92*1u' L=ln_min ad='arean(.92,sdd)'
+ as='arean(.92,sdd)' pd='perin(.92,sdd)' ps='perin(.92,sdd)'
M_1 out in1 net_1 gnd n W='1.38*1u' L=ln_min ad='arean(1.38,sdd)'
+ as='arean(1.38,sdd)' pd='perin(1.38,sdd)' ps='perin(1.38,sdd)'
M_2 out in1 net_2 gnd n W='1.38*1u' L=ln_min ad='arean(1.38,sdd)'
+ as='arean(1.38,sdd)' pd='perin(1.38,sdd)' ps='perin(1.38,sdd)'
M_3 net_2 in2 net_3 gnd n W='1.38*1u' L=ln_min ad='arean(1.38,sdd)'
+ as='arean(1.38,sdd)' pd='perin(1.38,sdd)' ps='perin(1.38,sdd)'
M_4 net_1 in2 net_4 gnd n W='1.38*1u' L=ln_min ad='arean(1.38,sdd)'
+ as='arean(1.38,sdd)' pd='perin(1.38,sdd)' ps='perin(1.38,sdd)'
M_5 net_4 in3 gnd gnd n W='1.38*1u' L=ln_min ad='arean(1.38,sdd)'
+ as='arean(1.38,sdd)' pd='perin(1.38,sdd)' ps='perin(1.38,sdd)'
M_6 net_3 in3 gnd gnd n W='1.38*1u' L=ln_min ad='arean(1.38,sdd)'
+ as='arean(1.38,sdd)' pd='perin(1.38,sdd)' ps='perin(1.38,sdd)'
M_7 out in0 net_5 vdd p W='1.84*1u' L=lp_min ad='areap(1.84,sdd)'
+ as='areap(1.84,sdd)' pd='perip(1.84,sdd)' ps='perip(1.84,sdd)'
M_8 out in0 net_5 vdd p W='1.84*1u' L=lp_min ad='areap(1.84,sdd)'
+ as='areap(1.84,sdd)' pd='perip(1.84,sdd)' ps='perip(1.84,sdd)'
M_9 net_5 in1 vdd vdd p W='1.84*1u' L=lp_min ad='areap(1.84,sdd)'
+ as='areap(1.84,sdd)' pd='perip(1.84,sdd)' ps='perip(1.84,sdd)'
M_10 net_5 in1 vdd vdd p W='1.84*1u' L=lp_min ad='areap(1.84,sdd)'
+ as='areap(1.84,sdd)' pd='perip(1.84,sdd)' ps='perip(1.84,sdd)'
M_11 net_5 in2 vdd vdd p W='1.84*1u' L=lp_min ad='areap(1.84,sdd)'
+ as='areap(1.84,sdd)' pd='perip(1.84,sdd)' ps='perip(1.84,sdd)'
M_12 net_5 in2 vdd vdd p W='1.84*1u' L=lp_min ad='areap(1.84,sdd)'
+ as='areap(1.84,sdd)' pd='perip(1.84,sdd)' ps='perip(1.84,sdd)'
M_13 net_5 in3 vdd vdd p W='1.84*1u' L=lp_min ad='areap(1.84,sdd)'
+ as='areap(1.84,sdd)' pd='perip(1.84,sdd)' ps='perip(1.84,sdd)'
M_14 net_5 in3 vdd vdd p W='1.84*1u' L=lp_min ad='areap(1.84,sdd)'
+ as='areap(1.84,sdd)' pd='perip(1.84,sdd)' ps='perip(1.84,sdd)'
.ENDS	$ MMI_AOI31B

.GLOBAL gnd vdd
