* FILE: MMI_MUXI2A.sp

* SPICE netlist for "MMI_MUXI2A" (generated by MMI_SUE4.1.5)

.SUBCKT inverter in out WP=2 LP=lp_min WN=1 LN=ln_min
M_0 out in gnd gnd n W='WN*1u' L=LN ad='arean(WN,sdd)' as='arean(WN,sdd)'
+ pd='perin(WN,sdd)' ps='perin(WN,sdd)'
M_1 out in vdd vdd p W='WP*1u' L=LP ad='areap(WP,sdd)' as='areap(WP,sdd)'
+ pd='perip(WP,sdd)' ps='perip(WP,sdd)'
.ENDS	$ inverter

.SUBCKT xgate in in_L t1 t2 WP=2 WN=1
M_0 t2 in_L t1 vdd p W='WP*1u' L=lp_min ad='areap(WP,sdd)'
+ as='areap(WP,sdd)' pd='perip(WP,sdd)' ps='perip(WP,sdd)'
M_1 t2 in t1 gnd n W='WN*1u' L=ln_min ad='arean(WN,sdd)' as='arean(WN,sdd)'
+ pd='perin(WN,sdd)' ps='perin(WN,sdd)'
.ENDS	$ xgate

.SUBCKT MMI_MUXI2A in0 in1 out sel
Xinverter sel net_1 inverter WP=0.92 WN=0.46
Xxgate net_1 sel net_2 out xgate WP=1.84 WN=0.92
Xinverter_1 in0 net_2 inverter WP=1.84 WN=0.92
Xinverter_2 in1 net_3 inverter WP=1.84 WN=0.92
Xxgate_1 sel net_1 net_3 out xgate WP=1.84 WN=0.92
.ENDS	$ MMI_MUXI2A

.GLOBAL gnd vdd
