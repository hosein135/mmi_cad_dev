* FILE: MMI_TSBUFC.sp

* SPICE netlist for "MMI_TSBUFC" (generated by MMI_SUE4.1.6)

.SUBCKT MMI_TSBUFC en enb in out
M_0 out N2 vdd vdd p W='3.68*1u' L=lp_min ad='areap(3.68,sdd)'
+ as='areap(3.68,sdd)' pd='perip(3.68,sdd)' ps='perip(3.68,sdd)'
M_1 out N1 gnd gnd n W='1.84*1u' L=ln_min ad='arean(1.84,sdd)'
+ as='arean(1.84,sdd)' pd='perin(1.84,sdd)' ps='perin(1.84,sdd)'
M_2 N2 en vdd vdd p W='0.84*1u' L=lp_min ad='areap(0.84,sdd)'
+ as='areap(0.84,sdd)' pd='perip(0.84,sdd)' ps='perip(0.84,sdd)'
M_3 N1 enb N2 vdd p W='0.84*1u' L=lp_min ad='areap(0.84,sdd)'
+ as='areap(0.84,sdd)' pd='perip(0.84,sdd)' ps='perip(0.84,sdd)'
M_4 N2 en N1 gnd n W='.42*1u' L=ln_min ad='arean(.42,sdd)'
+ as='arean(.42,sdd)' pd='perin(.42,sdd)' ps='perin(.42,sdd)'
M_5 N1 enb gnd gnd n W='.42*1u' L=ln_min ad='arean(.42,sdd)'
+ as='arean(.42,sdd)' pd='perin(.42,sdd)' ps='perin(.42,sdd)'
M_6 N2 in vdd vdd p W='1.68*1u' L=lp_min ad='areap(1.68,sdd)'
+ as='areap(1.68,sdd)' pd='perip(1.68,sdd)' ps='perip(1.68,sdd)'
M_7 N1 in gnd gnd n W='.84*1u' L=ln_min ad='arean(.84,sdd)'
+ as='arean(.84,sdd)' pd='perin(.84,sdd)' ps='perin(.84,sdd)'
.ENDS	$ MMI_TSBUFC

.GLOBAL gnd vdd
