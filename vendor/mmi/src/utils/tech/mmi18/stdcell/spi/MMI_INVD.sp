* FILE: MMI_INVD.sp

* SPICE netlist for "MMI_INVD" (generated by MMI_SUE4.1.5)

.SUBCKT MMI_INVD in out
M_0 out in gnd gnd n W='3.68*1u' L=ln_min ad='arean(3.68,sdd)'
+ as='arean(3.68,sdd)' pd='perin(3.68,sdd)' ps='perin(3.68,sdd)'
M_1 out in vdd vdd p W='7.36*1u' L=lp_min ad='areap(7.36,sdd)'
+ as='areap(7.36,sdd)' pd='perip(7.36,sdd)' ps='perip(7.36,sdd)'
.ENDS	$ MMI_INVD

.GLOBAL gnd vdd
