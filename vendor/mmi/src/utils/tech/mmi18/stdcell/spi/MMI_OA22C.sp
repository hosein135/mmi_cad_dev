* FILE: MMI_OA22C.sp

* SPICE netlist for "MMI_OA22C" (generated by MMI_SUE4.1.5)

.SUBCKT inverter1 in out WP=2 LP=lp_min WN=1 LN=ln_min
M_0 out in gnd gnd n W='WN*1u' L=LN ad='arean(WN,sdd)' as='arean(WN,sdd)'
+ pd='perin(WN,sdd)' ps='perin(WN,sdd)'
M_1 out in vdd vdd p W='WP*1u' L=LP ad='areap(WP,sdd)' as='areap(WP,sdd)'
+ pd='perip(WP,sdd)' ps='perip(WP,sdd)'
.ENDS	$ inverter1

.SUBCKT MMI_OA22C in0 in1 in2 in3 out
Xinverter1 N1 out inverter1 WP=3.68 WN=1.84
M_0 N1 in0 net_1 gnd n W='1.24*1u' L=ln_min ad='arean(1.24,sdd)'
+ as='arean(1.24,sdd)' pd='perin(1.24,sdd)' ps='perin(1.24,sdd)'
M_1 net_1 in2 gnd gnd n W='1.24*1u' L=ln_min ad='arean(1.24,sdd)'
+ as='arean(1.24,sdd)' pd='perin(1.24,sdd)' ps='perin(1.24,sdd)'
M_2 net_1 in3 gnd gnd n W='1.24*1u' L=ln_min ad='arean(1.24,sdd)'
+ as='arean(1.24,sdd)' pd='perin(1.24,sdd)' ps='perin(1.24,sdd)'
M_3 N1 in1 net_1 gnd n W='1.24*1u' L=ln_min ad='arean(1.24,sdd)'
+ as='arean(1.24,sdd)' pd='perin(1.24,sdd)' ps='perin(1.24,sdd)'
M_4 N1 in0 net_2 vdd p W='2.48*1u' L=lp_min ad='areap(2.48,sdd)'
+ as='areap(2.48,sdd)' pd='perip(2.48,sdd)' ps='perip(2.48,sdd)'
M_5 net_2 in1 vdd vdd p W='2.48*1u' L=lp_min ad='areap(2.48,sdd)'
+ as='areap(2.48,sdd)' pd='perip(2.48,sdd)' ps='perip(2.48,sdd)'
M_6 net_3 in3 vdd vdd p W='2.48*1u' L=lp_min ad='areap(2.48,sdd)'
+ as='areap(2.48,sdd)' pd='perip(2.48,sdd)' ps='perip(2.48,sdd)'
M_7 N1 in2 net_3 vdd p W='2.48*1u' L=lp_min ad='areap(2.48,sdd)'
+ as='areap(2.48,sdd)' pd='perip(2.48,sdd)' ps='perip(2.48,sdd)'
.ENDS	$ MMI_OA22C

.GLOBAL gnd vdd
