* FILE: MMI_NAND2C.sp

* SPICE netlist for "MMI_NAND2C" (generated by MMI_SUE4.1.5)

.SUBCKT MMI_NAND2C in0 in1 out
M_0 out in0 net_1 gnd n W='1.84*1u' L=ln_min ad='arean(1.84,sdd)'
+ as='arean(1.84,sdd)' pd='perin(1.84,sdd)' ps='perin(1.84,sdd)'
M_1 out in0 net_2 gnd n W='1.84*1u' L=ln_min ad='arean(1.84,sdd)'
+ as='arean(1.84,sdd)' pd='perin(1.84,sdd)' ps='perin(1.84,sdd)'
M_2 net_2 in1 gnd gnd n W='1.84*1u' L=ln_min ad='arean(1.84,sdd)'
+ as='arean(1.84,sdd)' pd='perin(1.84,sdd)' ps='perin(1.84,sdd)'
M_3 net_1 in1 gnd gnd n W='1.84*1u' L=ln_min ad='arean(1.84,sdd)'
+ as='arean(1.84,sdd)' pd='perin(1.84,sdd)' ps='perin(1.84,sdd)'
M_4 out in0 vdd vdd p W='3.68*1u' L=lp_min ad='areap(3.68,sdd)'
+ as='areap(3.68,sdd)' pd='perip(3.68,sdd)' ps='perip(3.68,sdd)'
M_5 out in1 vdd vdd p W='3.68*1u' L=lp_min ad='areap(3.68,sdd)'
+ as='areap(3.68,sdd)' pd='perip(3.68,sdd)' ps='perip(3.68,sdd)'
.ENDS	$ MMI_NAND2C

.GLOBAL gnd vdd
