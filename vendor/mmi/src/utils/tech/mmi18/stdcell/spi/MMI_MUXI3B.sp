* FILE: MMI_MUXI3B.sp

* SPICE netlist for "MMI_MUXI3B" (generated by MMI_SUE4.1.5)

.SUBCKT xgate in in_L t1 t2 WP=2 WN=1
M_0 t2 in_L t1 vdd p W='WP*1u' L=lp_min ad='areap(WP,sdd)'
+ as='areap(WP,sdd)' pd='perip(WP,sdd)' ps='perip(WP,sdd)'
M_1 t2 in t1 gnd n W='WN*1u' L=ln_min ad='arean(WN,sdd)' as='arean(WN,sdd)'
+ pd='perin(WN,sdd)' ps='perin(WN,sdd)'
.ENDS	$ xgate

.SUBCKT inverter in out WP=2 LP=lp_min WN=1 LN=ln_min
M_0 out in gnd gnd n W='WN*1u' L=LN ad='arean(WN,sdd)' as='arean(WN,sdd)'
+ pd='perin(WN,sdd)' ps='perin(WN,sdd)'
M_1 out in vdd vdd p W='WP*1u' L=LP ad='areap(WP,sdd)' as='areap(WP,sdd)'
+ pd='perip(WP,sdd)' ps='perip(WP,sdd)'
.ENDS	$ inverter

.SUBCKT MMI_MUXI3B in0 in1 in2 out sel0 sel1
Xxgate sel1_L sel1 N1 N2 xgate WP=1.84 WN=0.92
Xxgate_1 sel1 sel1_L in2_L N2 xgate WP=1.84 WN=0.92
Xinverter net_1 in2_L inverter WP=1.84 WN=0.92
Xinverter_1 sel1 sel1_L inverter WP=0.92 WN=0.46
Xxgate_2 net_3 sel0 net_4 net_2 xgate WP=1.84 WN=0.92
Xinverter_2 in0 net_4 inverter WP=1.84 WN=0.92
Xxgate_3 sel0 net_3 net_5 net_2 xgate WP=1.84 WN=0.92
Xinverter_3 in1 net_5 inverter WP=1.84 WN=0.92
Xinverter_4 sel0 net_3 inverter WP=0.92 WN=0.46
Xinverter_5 N2 out inverter WP=1.84 WN=0.92
Xinverter_6 net_2 N1 inverter WP=1.84 WN=0.92
Xinverter_7 in2 net_1 inverter WP=0.92 WN=0.46
.ENDS	$ MMI_MUXI3B

.GLOBAL gnd vdd
