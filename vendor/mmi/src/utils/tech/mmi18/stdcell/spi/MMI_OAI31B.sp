* FILE: MMI_OAI31B.sp

* SPICE netlist for "MMI_OAI31B" (generated by MMI_SUE4.1.5)

.SUBCKT MMI_OAI31B in0 in1 in2 in3 out
M_0 out in0 net_1 gnd n W='1.84*1u' L=ln_min ad='arean(1.84,sdd)'
+ as='arean(1.84,sdd)' pd='perin(1.84,sdd)' ps='perin(1.84,sdd)'
M_1 net_1 in1 gnd gnd n W='1.84*1u' L=ln_min ad='arean(1.84,sdd)'
+ as='arean(1.84,sdd)' pd='perin(1.84,sdd)' ps='perin(1.84,sdd)'
M_2 net_1 in2 gnd gnd n W='1.84*1u' L=ln_min ad='arean(1.84,sdd)'
+ as='arean(1.84,sdd)' pd='perin(1.84,sdd)' ps='perin(1.84,sdd)'
M_3 net_1 in3 gnd gnd n W='1.84*1u' L=ln_min ad='arean(1.84,sdd)'
+ as='arean(1.84,sdd)' pd='perin(1.84,sdd)' ps='perin(1.84,sdd)'
M_4 out in0 vdd vdd p W='1.84*1u' L=lp_min ad='areap(1.84,sdd)'
+ as='areap(1.84,sdd)' pd='perip(1.84,sdd)' ps='perip(1.84,sdd)'
M_5 out in1 net_2 vdd p W='1.38*1u' L=lp_min ad='areap(1.38,sdd)'
+ as='areap(1.38,sdd)' pd='perip(1.38,sdd)' ps='perip(1.38,sdd)'
M_6 out in1 net_3 vdd p W='1.38*1u' L=lp_min ad='areap(1.38,sdd)'
+ as='areap(1.38,sdd)' pd='perip(1.38,sdd)' ps='perip(1.38,sdd)'
M_7 out in1 net_4 vdd p W='1.38*1u' L=lp_min ad='areap(1.38,sdd)'
+ as='areap(1.38,sdd)' pd='perip(1.38,sdd)' ps='perip(1.38,sdd)'
M_8 out in1 net_5 vdd p W='1.38*1u' L=lp_min ad='areap(1.38,sdd)'
+ as='areap(1.38,sdd)' pd='perip(1.38,sdd)' ps='perip(1.38,sdd)'
M_9 net_2 in2 net_6 vdd p W='1.38*1u' L=lp_min ad='areap(1.38,sdd)'
+ as='areap(1.38,sdd)' pd='perip(1.38,sdd)' ps='perip(1.38,sdd)'
M_10 net_3 in2 net_7 vdd p W='1.38*1u' L=lp_min ad='areap(1.38,sdd)'
+ as='areap(1.38,sdd)' pd='perip(1.38,sdd)' ps='perip(1.38,sdd)'
M_11 net_4 in2 net_8 vdd p W='1.38*1u' L=lp_min ad='areap(1.38,sdd)'
+ as='areap(1.38,sdd)' pd='perip(1.38,sdd)' ps='perip(1.38,sdd)'
M_12 net_5 in2 net_9 vdd p W='1.38*1u' L=lp_min ad='areap(1.38,sdd)'
+ as='areap(1.38,sdd)' pd='perip(1.38,sdd)' ps='perip(1.38,sdd)'
M_13 net_9 in3 vdd vdd p W='1.38*1u' L=lp_min ad='areap(1.38,sdd)'
+ as='areap(1.38,sdd)' pd='perip(1.38,sdd)' ps='perip(1.38,sdd)'
M_14 net_8 in3 vdd vdd p W='1.38*1u' L=lp_min ad='areap(1.38,sdd)'
+ as='areap(1.38,sdd)' pd='perip(1.38,sdd)' ps='perip(1.38,sdd)'
M_15 net_7 in3 vdd vdd p W='1.38*1u' L=lp_min ad='areap(1.38,sdd)'
+ as='areap(1.38,sdd)' pd='perip(1.38,sdd)' ps='perip(1.38,sdd)'
M_16 net_6 in3 vdd vdd p W='1.38*1u' L=lp_min ad='areap(1.38,sdd)'
+ as='areap(1.38,sdd)' pd='perip(1.38,sdd)' ps='perip(1.38,sdd)'
.ENDS	$ MMI_OAI31B

.GLOBAL gnd vdd
