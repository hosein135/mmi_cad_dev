* FILE: MMI_INVB.sp

* SPICE netlist for "MMI_INVB" (generated by MMI_SUE4.1.5)

.SUBCKT MMI_INVB in out
M_0 out in vdd vdd p W='1.84*1u' L=lp_min ad='areap(1.84,sdd)'
+ as='areap(1.84,sdd)' pd='perip(1.84,sdd)' ps='perip(1.84,sdd)'
M_1 out in gnd gnd n W='.92*1u' L=ln_min ad='arean(.92,sdd)'
+ as='arean(.92,sdd)' pd='perin(.92,sdd)' ps='perin(.92,sdd)'
.ENDS	$ MMI_INVB

.GLOBAL gnd vdd
