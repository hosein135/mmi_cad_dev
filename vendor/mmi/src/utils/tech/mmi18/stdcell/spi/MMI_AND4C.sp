* FILE: MMI_AND4C.sp

* SPICE netlist for "MMI_AND4C" (generated by MMI_SUE4.1.5)

.SUBCKT inverter1 in out WP=2 LP=lp_min WN=1 LN=ln_min
M_0 out in gnd gnd n W='WN*1u' L=LN ad='arean(WN,sdd)' as='arean(WN,sdd)'
+ pd='perin(WN,sdd)' ps='perin(WN,sdd)'
M_1 out in vdd vdd p W='WP*1u' L=LP ad='areap(WP,sdd)' as='areap(WP,sdd)'
+ pd='perip(WP,sdd)' ps='perip(WP,sdd)'
.ENDS	$ inverter1

.SUBCKT MMI_AND4C in0 in1 in2 in3 out
Xinverter1 N1 out inverter1 WP=3.68 WN=1.84
M_0 N1 in3 vdd vdd p W='1.24*1u' L=lp_min ad='areap(1.24,sdd)'
+ as='areap(1.24,sdd)' pd='perip(1.24,sdd)' ps='perip(1.24,sdd)'
M_1 N1 in2 vdd vdd p W='1.24*1u' L=lp_min ad='areap(1.24,sdd)'
+ as='areap(1.24,sdd)' pd='perip(1.24,sdd)' ps='perip(1.24,sdd)'
M_2 N1 in1 vdd vdd p W='1.24*1u' L=lp_min ad='areap(1.24,sdd)'
+ as='areap(1.24,sdd)' pd='perip(1.24,sdd)' ps='perip(1.24,sdd)'
M_3 N1 in0 vdd vdd p W='1.24*1u' L=lp_min ad='areap(1.24,sdd)'
+ as='areap(1.24,sdd)' pd='perip(1.24,sdd)' ps='perip(1.24,sdd)'
M_4 N1 in0 net_1 gnd n W='1.24*1u' L=ln_min ad='arean(1.24,sdd)'
+ as='arean(1.24,sdd)' pd='perin(1.24,sdd)' ps='perin(1.24,sdd)'
M_5 N1 in0 net_2 gnd n W='1.24*1u' L=ln_min ad='arean(1.24,sdd)'
+ as='arean(1.24,sdd)' pd='perin(1.24,sdd)' ps='perin(1.24,sdd)'
M_6 net_2 in1 net_3 gnd n W='1.24*1u' L=ln_min ad='arean(1.24,sdd)'
+ as='arean(1.24,sdd)' pd='perin(1.24,sdd)' ps='perin(1.24,sdd)'
M_7 net_1 in1 net_4 gnd n W='1.24*1u' L=ln_min ad='arean(1.24,sdd)'
+ as='arean(1.24,sdd)' pd='perin(1.24,sdd)' ps='perin(1.24,sdd)'
M_8 net_3 in2 net_5 gnd n W='1.24*1u' L=ln_min ad='arean(1.24,sdd)'
+ as='arean(1.24,sdd)' pd='perin(1.24,sdd)' ps='perin(1.24,sdd)'
M_9 net_4 in2 net_6 gnd n W='1.24*1u' L=ln_min ad='arean(1.24,sdd)'
+ as='arean(1.24,sdd)' pd='perin(1.24,sdd)' ps='perin(1.24,sdd)'
M_10 net_5 in3 gnd gnd n W='1.24*1u' L=ln_min ad='arean(1.24,sdd)'
+ as='arean(1.24,sdd)' pd='perin(1.24,sdd)' ps='perin(1.24,sdd)'
M_11 net_6 in3 gnd gnd n W='1.24*1u' L=ln_min ad='arean(1.24,sdd)'
+ as='arean(1.24,sdd)' pd='perin(1.24,sdd)' ps='perin(1.24,sdd)'
.ENDS	$ MMI_AND4C

.GLOBAL gnd vdd
