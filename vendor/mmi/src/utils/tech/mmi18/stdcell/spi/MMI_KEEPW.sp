* FILE: MMI_KEEPW.sp

* SPICE netlist for "MMI_KEEPW" (generated by MMI_SUE4.1.5)

.SUBCKT MMI_KEEPW in
M_0 in net_1 vdd vdd p W='.42*1u' L=lp_min ad='areap(.42,sdd)'
+ as='areap(.42,sdd)' pd='perip(.42,sdd)' ps='perip(.42,sdd)'
M_1 net_1 in vdd vdd p W='.42*1u' L=lp_min ad='areap(.42,sdd)'
+ as='areap(.42,sdd)' pd='perip(.42,sdd)' ps='perip(.42,sdd)'
M_2 in net_1 gnd gnd n W='0.42*1u' L='2*ln_min' ad='arean(0.42,sdd)'
+ as='arean(0.42,sdd)' pd='perin(0.42,sdd)' ps='perin(0.42,sdd)'
M_3 net_1 in gnd gnd n W='0.42*1u' L='2*ln_min' ad='arean(0.42,sdd)'
+ as='arean(0.42,sdd)' pd='perin(0.42,sdd)' ps='perin(0.42,sdd)'
.ENDS	$ MMI_KEEPW

.GLOBAL gnd vdd
