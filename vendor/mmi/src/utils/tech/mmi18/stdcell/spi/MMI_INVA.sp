* FILE: MMI_INVA.sp

* SPICE netlist for "MMI_INVA" (generated by MMI_SUE4.1.5)

.SUBCKT MMI_INVA in out
M_0 out in vdd vdd p W='.92*1u' L=lp_min ad='areap(.92,sdd)'
+ as='areap(.92,sdd)' pd='perip(.92,sdd)' ps='perip(.92,sdd)'
M_1 out in gnd gnd n W='0.46*1u' L=ln_min ad='arean(0.46,sdd)'
+ as='arean(0.46,sdd)' pd='perin(0.46,sdd)' ps='perin(0.46,sdd)'
.ENDS	$ MMI_INVA

.GLOBAL gnd vdd
