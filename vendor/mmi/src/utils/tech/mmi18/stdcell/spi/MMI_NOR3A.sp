* FILE: MMI_NOR3A.sp

* SPICE netlist for "MMI_NOR3A" (generated by MMI_SUE4.1.5)

.SUBCKT MMI_NOR3A in0 in1 in2 out
M_0 out in0 gnd gnd n W='0.46*1u' L=ln_min ad='arean(0.46,sdd)'
+ as='arean(0.46,sdd)' pd='perin(0.46,sdd)' ps='perin(0.46,sdd)'
M_1 out in1 gnd gnd n W='0.46*1u' L=ln_min ad='arean(0.46,sdd)'
+ as='arean(0.46,sdd)' pd='perin(0.46,sdd)' ps='perin(0.46,sdd)'
M_2 out in2 gnd gnd n W='0.46*1u' L=ln_min ad='arean(0.46,sdd)'
+ as='arean(0.46,sdd)' pd='perin(0.46,sdd)' ps='perin(0.46,sdd)'
M_3 out in0 net_1 vdd p W='2.76*1u' L=lp_min ad='areap(2.76,sdd)'
+ as='areap(2.76,sdd)' pd='perip(2.76,sdd)' ps='perip(2.76,sdd)'
M_4 net_1 in1 net_2 vdd p W='2.76*1u' L=lp_min ad='areap(2.76,sdd)'
+ as='areap(2.76,sdd)' pd='perip(2.76,sdd)' ps='perip(2.76,sdd)'
M_5 net_2 in2 vdd vdd p W='2.76*1u' L=lp_min ad='areap(2.76,sdd)'
+ as='areap(2.76,sdd)' pd='perip(2.76,sdd)' ps='perip(2.76,sdd)'
.ENDS	$ MMI_NOR3A

.GLOBAL gnd vdd
