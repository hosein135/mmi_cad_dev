* FILE: MMI_NOR3B.sp

* SPICE netlist for "MMI_NOR3B" (generated by MMI_SUE4.1.5)

.SUBCKT MMI_NOR3B in0 in1 in2 out
M_0 out in0 gnd gnd n W='.92*1u' L=ln_min ad='arean(.92,sdd)'
+ as='arean(.92,sdd)' pd='perin(.92,sdd)' ps='perin(.92,sdd)'
M_1 out in1 gnd gnd n W='.92*1u' L=ln_min ad='arean(.92,sdd)'
+ as='arean(.92,sdd)' pd='perin(.92,sdd)' ps='perin(.92,sdd)'
M_2 out in2 gnd gnd n W='.92*1u' L=ln_min ad='arean(.92,sdd)'
+ as='arean(.92,sdd)' pd='perin(.92,sdd)' ps='perin(.92,sdd)'
M_3 out in0 net_1 vdd p W='1.84*1u' L=lp_min ad='areap(1.84,sdd)'
+ as='areap(1.84,sdd)' pd='perip(1.84,sdd)' ps='perip(1.84,sdd)'
M_4 out in0 net_2 vdd p W='1.84*1u' L=lp_min ad='areap(1.84,sdd)'
+ as='areap(1.84,sdd)' pd='perip(1.84,sdd)' ps='perip(1.84,sdd)'
M_5 out in0 net_3 vdd p W='1.84*1u' L=lp_min ad='areap(1.84,sdd)'
+ as='areap(1.84,sdd)' pd='perip(1.84,sdd)' ps='perip(1.84,sdd)'
M_6 net_1 in1 net_4 vdd p W='1.84*1u' L=lp_min ad='areap(1.84,sdd)'
+ as='areap(1.84,sdd)' pd='perip(1.84,sdd)' ps='perip(1.84,sdd)'
M_7 net_2 in1 net_5 vdd p W='1.84*1u' L=lp_min ad='areap(1.84,sdd)'
+ as='areap(1.84,sdd)' pd='perip(1.84,sdd)' ps='perip(1.84,sdd)'
M_8 net_3 in1 net_6 vdd p W='1.84*1u' L=lp_min ad='areap(1.84,sdd)'
+ as='areap(1.84,sdd)' pd='perip(1.84,sdd)' ps='perip(1.84,sdd)'
M_9 net_4 in2 vdd vdd p W='1.84*1u' L=lp_min ad='areap(1.84,sdd)'
+ as='areap(1.84,sdd)' pd='perip(1.84,sdd)' ps='perip(1.84,sdd)'
M_10 net_5 in2 vdd vdd p W='1.84*1u' L=lp_min ad='areap(1.84,sdd)'
+ as='areap(1.84,sdd)' pd='perip(1.84,sdd)' ps='perip(1.84,sdd)'
M_11 net_6 in2 vdd vdd p W='1.84*1u' L=lp_min ad='areap(1.84,sdd)'
+ as='areap(1.84,sdd)' pd='perip(1.84,sdd)' ps='perip(1.84,sdd)'
.ENDS	$ MMI_NOR3B

.GLOBAL gnd vdd
