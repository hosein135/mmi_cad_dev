* FILE: MMI_NAND4A.sp

* SPICE netlist for "MMI_NAND4A" (generated by MMI_SUE4.1.5)

.SUBCKT MMI_NAND4A in0 in1 in2 in3 out
M_0 out in0 vdd vdd p W='.92*1u' L=lp_min ad='areap(.92,sdd)'
+ as='areap(.92,sdd)' pd='perip(.92,sdd)' ps='perip(.92,sdd)'
M_1 out in1 vdd vdd p W='.92*1u' L=lp_min ad='areap(.92,sdd)'
+ as='areap(.92,sdd)' pd='perip(.92,sdd)' ps='perip(.92,sdd)'
M_2 out in2 vdd vdd p W='.92*1u' L=lp_min ad='areap(.92,sdd)'
+ as='areap(.92,sdd)' pd='perip(.92,sdd)' ps='perip(.92,sdd)'
M_3 out in3 vdd vdd p W='.92*1u' L=lp_min ad='areap(.92,sdd)'
+ as='areap(.92,sdd)' pd='perip(.92,sdd)' ps='perip(.92,sdd)'
M_4 out in0 net_1 gnd n W='1.84*1u' L=ln_min ad='arean(1.84,sdd)'
+ as='arean(1.84,sdd)' pd='perin(1.84,sdd)' ps='perin(1.84,sdd)'
M_5 net_1 in1 net_2 gnd n W='1.84*1u' L=ln_min ad='arean(1.84,sdd)'
+ as='arean(1.84,sdd)' pd='perin(1.84,sdd)' ps='perin(1.84,sdd)'
M_6 net_2 in2 net_3 gnd n W='1.84*1u' L=ln_min ad='arean(1.84,sdd)'
+ as='arean(1.84,sdd)' pd='perin(1.84,sdd)' ps='perin(1.84,sdd)'
M_7 net_3 in3 gnd gnd n W='1.84*1u' L=ln_min ad='arean(1.84,sdd)'
+ as='arean(1.84,sdd)' pd='perin(1.84,sdd)' ps='perin(1.84,sdd)'
.ENDS	$ MMI_NAND4A

.GLOBAL gnd vdd
