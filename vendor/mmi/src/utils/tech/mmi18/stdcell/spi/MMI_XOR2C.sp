* FILE: MMI_XOR2C.sp

* SPICE netlist for "MMI_XOR2C" (generated by MMI_SUE4.1.5)

.SUBCKT MMI_AOI21C in0 in1 in2 out
M_0 out in0 gnd gnd n W='1.84*1u' L=ln_min ad='arean(1.84,sdd)'
+ as='arean(1.84,sdd)' pd='perin(1.84,sdd)' ps='perin(1.84,sdd)'
M_1 out in1 net_1 gnd n W='3.68*1u' L=ln_min ad='arean(3.68,sdd)'
+ as='arean(3.68,sdd)' pd='perin(3.68,sdd)' ps='perin(3.68,sdd)'
M_2 net_1 in2 gnd gnd n W='3.68*1u' L=ln_min ad='arean(3.68,sdd)'
+ as='arean(3.68,sdd)' pd='perin(3.68,sdd)' ps='perin(3.68,sdd)'
M_3 out in0 net_2 vdd p W='7.36*1u' L=lp_min ad='areap(7.36,sdd)'
+ as='areap(7.36,sdd)' pd='perip(7.36,sdd)' ps='perip(7.36,sdd)'
M_4 net_2 in2 vdd vdd p W='7.36*1u' L=lp_min ad='areap(7.36,sdd)'
+ as='areap(7.36,sdd)' pd='perip(7.36,sdd)' ps='perip(7.36,sdd)'
M_5 net_2 in1 vdd vdd p W='7.36*1u' L=lp_min ad='areap(7.36,sdd)'
+ as='areap(7.36,sdd)' pd='perip(7.36,sdd)' ps='perip(7.36,sdd)'
.ENDS	$ MMI_AOI21C

.SUBCKT MMI_NOR2B in0 in1 out
M_0 out in0 gnd gnd n W='.92*1u' L=ln_min ad='arean(.92,sdd)'
+ as='arean(.92,sdd)' pd='perin(.92,sdd)' ps='perin(.92,sdd)'
M_1 out in1 gnd gnd n W='.92*1u' L=ln_min ad='arean(.92,sdd)'
+ as='arean(.92,sdd)' pd='perin(.92,sdd)' ps='perin(.92,sdd)'
M_2 out in0 net_1 vdd p W='1.84*1u' L=lp_min ad='areap(1.84,sdd)'
+ as='areap(1.84,sdd)' pd='perip(1.84,sdd)' ps='perip(1.84,sdd)'
M_3 out in0 net_2 vdd p W='1.84*1u' L=lp_min ad='areap(1.84,sdd)'
+ as='areap(1.84,sdd)' pd='perip(1.84,sdd)' ps='perip(1.84,sdd)'
M_4 net_1 in1 vdd vdd p W='1.84*1u' L=lp_min ad='areap(1.84,sdd)'
+ as='areap(1.84,sdd)' pd='perip(1.84,sdd)' ps='perip(1.84,sdd)'
M_5 net_2 in1 vdd vdd p W='1.84*1u' L=lp_min ad='areap(1.84,sdd)'
+ as='areap(1.84,sdd)' pd='perip(1.84,sdd)' ps='perip(1.84,sdd)'
.ENDS	$ MMI_NOR2B

.SUBCKT MMI_XOR2C in0 in1 out
XMMI_AOI21C net_1 in1 in0 out MMI_AOI21C
XMMI_NOR2B in0 in1 net_1 MMI_NOR2B
.ENDS	$ MMI_XOR2C

.GLOBAL gnd vdd
