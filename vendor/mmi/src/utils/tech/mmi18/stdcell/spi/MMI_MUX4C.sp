* FILE: MMI_MUX4C.sp

* SPICE netlist for "MMI_MUX4C" (generated by MMI_SUE4.1.5)

.SUBCKT inverter in out WP=2 LP=lp_min WN=1 LN=ln_min
M_0 out in gnd gnd n W='WN*1u' L=LN ad='arean(WN,sdd)' as='arean(WN,sdd)'
+ pd='perin(WN,sdd)' ps='perin(WN,sdd)'
M_1 out in vdd vdd p W='WP*1u' L=LP ad='areap(WP,sdd)' as='areap(WP,sdd)'
+ pd='perip(WP,sdd)' ps='perip(WP,sdd)'
.ENDS	$ inverter

.SUBCKT xgate in in_L t1 t2 WP=2 WN=1
M_0 t2 in_L t1 vdd p W='WP*1u' L=lp_min ad='areap(WP,sdd)'
+ as='areap(WP,sdd)' pd='perip(WP,sdd)' ps='perip(WP,sdd)'
M_1 t2 in t1 gnd n W='WN*1u' L=ln_min ad='arean(WN,sdd)' as='arean(WN,sdd)'
+ pd='perin(WN,sdd)' ps='perin(WN,sdd)'
.ENDS	$ xgate

.SUBCKT MMI_MUX4C in0 in1 in2 in3 out sel0 sel1
Xinverter N2 out inverter WP=3.68 WN=1.84
Xinverter_1 in3 net_1 inverter WP=3.68 WN=1.84
Xinverter_2 in2 net_2 inverter WP=3.68 WN=1.84
Xinverter_3 in1 net_3 inverter WP=3.68 WN=1.84
Xinverter_4 in0 net_4 inverter WP=3.68 WN=1.84
Xxgate sel0 net_5 net_3 N1 xgate WP=3.68 WN=1.84
Xxgate_1 net_5 sel0 net_4 N1 xgate WP=3.68 WN=1.84
Xxgate_2 net_5 sel0 net_2 net_6 xgate WP=3.68 WN=1.84
Xxgate_3 sel0 net_5 net_1 net_6 xgate WP=3.68 WN=1.84
Xinverter_5 sel0 net_5 inverter WP=2.4 WN=1.2
Xxgate_4 sel1_L sel1 N1 N2 xgate WP=1.84 WN=0.92
Xxgate_5 sel1 sel1_L net_6 N2 xgate WP=1.84 WN=0.92
Xinverter_6 sel1 sel1_L inverter WP=0.92 WN=0.46
.ENDS	$ MMI_MUX4C

.GLOBAL gnd vdd
